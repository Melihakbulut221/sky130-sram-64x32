* Schematic netlist of the 64 x 32 bit-cell array (LVS reference)
.subckt sram_bitcell WL BL BLB VDD GND
Xpdl Q QB GND GND sky130_fd_pr__nfet_01v8 w=0.65 l=0.15
Xpul Q QB VDD VDD sky130_fd_pr__pfet_01v8_hvt w=0.42 l=0.15
Xpgl BL WL Q GND sky130_fd_pr__nfet_01v8 w=0.42 l=0.15
Xpdr QB Q GND GND sky130_fd_pr__nfet_01v8 w=0.65 l=0.15
Xpur QB Q VDD VDD sky130_fd_pr__pfet_01v8_hvt w=0.42 l=0.15
Xpgr BLB WL QB GND sky130_fd_pr__nfet_01v8 w=0.42 l=0.15
.ends

.subckt sram_array_64x32
+ WL[0] WL[1] WL[2] WL[3] WL[4] WL[5] WL[6] WL[7] WL[8] WL[9] WL[10] WL[11]
+ WL[12] WL[13] WL[14] WL[15] WL[16] WL[17] WL[18] WL[19] WL[20] WL[21] WL[22] WL[23]
+ WL[24] WL[25] WL[26] WL[27] WL[28] WL[29] WL[30] WL[31] WL[32] WL[33] WL[34] WL[35]
+ WL[36] WL[37] WL[38] WL[39] WL[40] WL[41] WL[42] WL[43] WL[44] WL[45] WL[46] WL[47]
+ WL[48] WL[49] WL[50] WL[51] WL[52] WL[53] WL[54] WL[55] WL[56] WL[57] WL[58] WL[59]
+ WL[60] WL[61] WL[62] WL[63] BL[0] BLB[0] BL[1] BLB[1] BL[2] BLB[2] BL[3] BLB[3]
+ BL[4] BLB[4] BL[5] BLB[5] BL[6] BLB[6] BL[7] BLB[7] BL[8] BLB[8] BL[9] BLB[9]
+ BL[10] BLB[10] BL[11] BLB[11] BL[12] BLB[12] BL[13] BLB[13] BL[14] BLB[14] BL[15] BLB[15]
+ BL[16] BLB[16] BL[17] BLB[17] BL[18] BLB[18] BL[19] BLB[19] BL[20] BLB[20] BL[21] BLB[21]
+ BL[22] BLB[22] BL[23] BLB[23] BL[24] BLB[24] BL[25] BLB[25] BL[26] BLB[26] BL[27] BLB[27]
+ BL[28] BLB[28] BL[29] BLB[29] BL[30] BLB[30] BL[31] BLB[31] VDD GND
Xbit_r0_c0 WL[0] BL[0] BLB[0] VDD GND sram_bitcell
Xbit_r0_c1 WL[0] BL[1] BLB[1] VDD GND sram_bitcell
Xbit_r0_c2 WL[0] BL[2] BLB[2] VDD GND sram_bitcell
Xbit_r0_c3 WL[0] BL[3] BLB[3] VDD GND sram_bitcell
Xbit_r0_c4 WL[0] BL[4] BLB[4] VDD GND sram_bitcell
Xbit_r0_c5 WL[0] BL[5] BLB[5] VDD GND sram_bitcell
Xbit_r0_c6 WL[0] BL[6] BLB[6] VDD GND sram_bitcell
Xbit_r0_c7 WL[0] BL[7] BLB[7] VDD GND sram_bitcell
Xbit_r0_c8 WL[0] BL[8] BLB[8] VDD GND sram_bitcell
Xbit_r0_c9 WL[0] BL[9] BLB[9] VDD GND sram_bitcell
Xbit_r0_c10 WL[0] BL[10] BLB[10] VDD GND sram_bitcell
Xbit_r0_c11 WL[0] BL[11] BLB[11] VDD GND sram_bitcell
Xbit_r0_c12 WL[0] BL[12] BLB[12] VDD GND sram_bitcell
Xbit_r0_c13 WL[0] BL[13] BLB[13] VDD GND sram_bitcell
Xbit_r0_c14 WL[0] BL[14] BLB[14] VDD GND sram_bitcell
Xbit_r0_c15 WL[0] BL[15] BLB[15] VDD GND sram_bitcell
Xbit_r0_c16 WL[0] BL[16] BLB[16] VDD GND sram_bitcell
Xbit_r0_c17 WL[0] BL[17] BLB[17] VDD GND sram_bitcell
Xbit_r0_c18 WL[0] BL[18] BLB[18] VDD GND sram_bitcell
Xbit_r0_c19 WL[0] BL[19] BLB[19] VDD GND sram_bitcell
Xbit_r0_c20 WL[0] BL[20] BLB[20] VDD GND sram_bitcell
Xbit_r0_c21 WL[0] BL[21] BLB[21] VDD GND sram_bitcell
Xbit_r0_c22 WL[0] BL[22] BLB[22] VDD GND sram_bitcell
Xbit_r0_c23 WL[0] BL[23] BLB[23] VDD GND sram_bitcell
Xbit_r0_c24 WL[0] BL[24] BLB[24] VDD GND sram_bitcell
Xbit_r0_c25 WL[0] BL[25] BLB[25] VDD GND sram_bitcell
Xbit_r0_c26 WL[0] BL[26] BLB[26] VDD GND sram_bitcell
Xbit_r0_c27 WL[0] BL[27] BLB[27] VDD GND sram_bitcell
Xbit_r0_c28 WL[0] BL[28] BLB[28] VDD GND sram_bitcell
Xbit_r0_c29 WL[0] BL[29] BLB[29] VDD GND sram_bitcell
Xbit_r0_c30 WL[0] BL[30] BLB[30] VDD GND sram_bitcell
Xbit_r0_c31 WL[0] BL[31] BLB[31] VDD GND sram_bitcell
Xbit_r1_c0 WL[1] BL[0] BLB[0] VDD GND sram_bitcell
Xbit_r1_c1 WL[1] BL[1] BLB[1] VDD GND sram_bitcell
Xbit_r1_c2 WL[1] BL[2] BLB[2] VDD GND sram_bitcell
Xbit_r1_c3 WL[1] BL[3] BLB[3] VDD GND sram_bitcell
Xbit_r1_c4 WL[1] BL[4] BLB[4] VDD GND sram_bitcell
Xbit_r1_c5 WL[1] BL[5] BLB[5] VDD GND sram_bitcell
Xbit_r1_c6 WL[1] BL[6] BLB[6] VDD GND sram_bitcell
Xbit_r1_c7 WL[1] BL[7] BLB[7] VDD GND sram_bitcell
Xbit_r1_c8 WL[1] BL[8] BLB[8] VDD GND sram_bitcell
Xbit_r1_c9 WL[1] BL[9] BLB[9] VDD GND sram_bitcell
Xbit_r1_c10 WL[1] BL[10] BLB[10] VDD GND sram_bitcell
Xbit_r1_c11 WL[1] BL[11] BLB[11] VDD GND sram_bitcell
Xbit_r1_c12 WL[1] BL[12] BLB[12] VDD GND sram_bitcell
Xbit_r1_c13 WL[1] BL[13] BLB[13] VDD GND sram_bitcell
Xbit_r1_c14 WL[1] BL[14] BLB[14] VDD GND sram_bitcell
Xbit_r1_c15 WL[1] BL[15] BLB[15] VDD GND sram_bitcell
Xbit_r1_c16 WL[1] BL[16] BLB[16] VDD GND sram_bitcell
Xbit_r1_c17 WL[1] BL[17] BLB[17] VDD GND sram_bitcell
Xbit_r1_c18 WL[1] BL[18] BLB[18] VDD GND sram_bitcell
Xbit_r1_c19 WL[1] BL[19] BLB[19] VDD GND sram_bitcell
Xbit_r1_c20 WL[1] BL[20] BLB[20] VDD GND sram_bitcell
Xbit_r1_c21 WL[1] BL[21] BLB[21] VDD GND sram_bitcell
Xbit_r1_c22 WL[1] BL[22] BLB[22] VDD GND sram_bitcell
Xbit_r1_c23 WL[1] BL[23] BLB[23] VDD GND sram_bitcell
Xbit_r1_c24 WL[1] BL[24] BLB[24] VDD GND sram_bitcell
Xbit_r1_c25 WL[1] BL[25] BLB[25] VDD GND sram_bitcell
Xbit_r1_c26 WL[1] BL[26] BLB[26] VDD GND sram_bitcell
Xbit_r1_c27 WL[1] BL[27] BLB[27] VDD GND sram_bitcell
Xbit_r1_c28 WL[1] BL[28] BLB[28] VDD GND sram_bitcell
Xbit_r1_c29 WL[1] BL[29] BLB[29] VDD GND sram_bitcell
Xbit_r1_c30 WL[1] BL[30] BLB[30] VDD GND sram_bitcell
Xbit_r1_c31 WL[1] BL[31] BLB[31] VDD GND sram_bitcell
Xbit_r2_c0 WL[2] BL[0] BLB[0] VDD GND sram_bitcell
Xbit_r2_c1 WL[2] BL[1] BLB[1] VDD GND sram_bitcell
Xbit_r2_c2 WL[2] BL[2] BLB[2] VDD GND sram_bitcell
Xbit_r2_c3 WL[2] BL[3] BLB[3] VDD GND sram_bitcell
Xbit_r2_c4 WL[2] BL[4] BLB[4] VDD GND sram_bitcell
Xbit_r2_c5 WL[2] BL[5] BLB[5] VDD GND sram_bitcell
Xbit_r2_c6 WL[2] BL[6] BLB[6] VDD GND sram_bitcell
Xbit_r2_c7 WL[2] BL[7] BLB[7] VDD GND sram_bitcell
Xbit_r2_c8 WL[2] BL[8] BLB[8] VDD GND sram_bitcell
Xbit_r2_c9 WL[2] BL[9] BLB[9] VDD GND sram_bitcell
Xbit_r2_c10 WL[2] BL[10] BLB[10] VDD GND sram_bitcell
Xbit_r2_c11 WL[2] BL[11] BLB[11] VDD GND sram_bitcell
Xbit_r2_c12 WL[2] BL[12] BLB[12] VDD GND sram_bitcell
Xbit_r2_c13 WL[2] BL[13] BLB[13] VDD GND sram_bitcell
Xbit_r2_c14 WL[2] BL[14] BLB[14] VDD GND sram_bitcell
Xbit_r2_c15 WL[2] BL[15] BLB[15] VDD GND sram_bitcell
Xbit_r2_c16 WL[2] BL[16] BLB[16] VDD GND sram_bitcell
Xbit_r2_c17 WL[2] BL[17] BLB[17] VDD GND sram_bitcell
Xbit_r2_c18 WL[2] BL[18] BLB[18] VDD GND sram_bitcell
Xbit_r2_c19 WL[2] BL[19] BLB[19] VDD GND sram_bitcell
Xbit_r2_c20 WL[2] BL[20] BLB[20] VDD GND sram_bitcell
Xbit_r2_c21 WL[2] BL[21] BLB[21] VDD GND sram_bitcell
Xbit_r2_c22 WL[2] BL[22] BLB[22] VDD GND sram_bitcell
Xbit_r2_c23 WL[2] BL[23] BLB[23] VDD GND sram_bitcell
Xbit_r2_c24 WL[2] BL[24] BLB[24] VDD GND sram_bitcell
Xbit_r2_c25 WL[2] BL[25] BLB[25] VDD GND sram_bitcell
Xbit_r2_c26 WL[2] BL[26] BLB[26] VDD GND sram_bitcell
Xbit_r2_c27 WL[2] BL[27] BLB[27] VDD GND sram_bitcell
Xbit_r2_c28 WL[2] BL[28] BLB[28] VDD GND sram_bitcell
Xbit_r2_c29 WL[2] BL[29] BLB[29] VDD GND sram_bitcell
Xbit_r2_c30 WL[2] BL[30] BLB[30] VDD GND sram_bitcell
Xbit_r2_c31 WL[2] BL[31] BLB[31] VDD GND sram_bitcell
Xbit_r3_c0 WL[3] BL[0] BLB[0] VDD GND sram_bitcell
Xbit_r3_c1 WL[3] BL[1] BLB[1] VDD GND sram_bitcell
Xbit_r3_c2 WL[3] BL[2] BLB[2] VDD GND sram_bitcell
Xbit_r3_c3 WL[3] BL[3] BLB[3] VDD GND sram_bitcell
Xbit_r3_c4 WL[3] BL[4] BLB[4] VDD GND sram_bitcell
Xbit_r3_c5 WL[3] BL[5] BLB[5] VDD GND sram_bitcell
Xbit_r3_c6 WL[3] BL[6] BLB[6] VDD GND sram_bitcell
Xbit_r3_c7 WL[3] BL[7] BLB[7] VDD GND sram_bitcell
Xbit_r3_c8 WL[3] BL[8] BLB[8] VDD GND sram_bitcell
Xbit_r3_c9 WL[3] BL[9] BLB[9] VDD GND sram_bitcell
Xbit_r3_c10 WL[3] BL[10] BLB[10] VDD GND sram_bitcell
Xbit_r3_c11 WL[3] BL[11] BLB[11] VDD GND sram_bitcell
Xbit_r3_c12 WL[3] BL[12] BLB[12] VDD GND sram_bitcell
Xbit_r3_c13 WL[3] BL[13] BLB[13] VDD GND sram_bitcell
Xbit_r3_c14 WL[3] BL[14] BLB[14] VDD GND sram_bitcell
Xbit_r3_c15 WL[3] BL[15] BLB[15] VDD GND sram_bitcell
Xbit_r3_c16 WL[3] BL[16] BLB[16] VDD GND sram_bitcell
Xbit_r3_c17 WL[3] BL[17] BLB[17] VDD GND sram_bitcell
Xbit_r3_c18 WL[3] BL[18] BLB[18] VDD GND sram_bitcell
Xbit_r3_c19 WL[3] BL[19] BLB[19] VDD GND sram_bitcell
Xbit_r3_c20 WL[3] BL[20] BLB[20] VDD GND sram_bitcell
Xbit_r3_c21 WL[3] BL[21] BLB[21] VDD GND sram_bitcell
Xbit_r3_c22 WL[3] BL[22] BLB[22] VDD GND sram_bitcell
Xbit_r3_c23 WL[3] BL[23] BLB[23] VDD GND sram_bitcell
Xbit_r3_c24 WL[3] BL[24] BLB[24] VDD GND sram_bitcell
Xbit_r3_c25 WL[3] BL[25] BLB[25] VDD GND sram_bitcell
Xbit_r3_c26 WL[3] BL[26] BLB[26] VDD GND sram_bitcell
Xbit_r3_c27 WL[3] BL[27] BLB[27] VDD GND sram_bitcell
Xbit_r3_c28 WL[3] BL[28] BLB[28] VDD GND sram_bitcell
Xbit_r3_c29 WL[3] BL[29] BLB[29] VDD GND sram_bitcell
Xbit_r3_c30 WL[3] BL[30] BLB[30] VDD GND sram_bitcell
Xbit_r3_c31 WL[3] BL[31] BLB[31] VDD GND sram_bitcell
Xbit_r4_c0 WL[4] BL[0] BLB[0] VDD GND sram_bitcell
Xbit_r4_c1 WL[4] BL[1] BLB[1] VDD GND sram_bitcell
Xbit_r4_c2 WL[4] BL[2] BLB[2] VDD GND sram_bitcell
Xbit_r4_c3 WL[4] BL[3] BLB[3] VDD GND sram_bitcell
Xbit_r4_c4 WL[4] BL[4] BLB[4] VDD GND sram_bitcell
Xbit_r4_c5 WL[4] BL[5] BLB[5] VDD GND sram_bitcell
Xbit_r4_c6 WL[4] BL[6] BLB[6] VDD GND sram_bitcell
Xbit_r4_c7 WL[4] BL[7] BLB[7] VDD GND sram_bitcell
Xbit_r4_c8 WL[4] BL[8] BLB[8] VDD GND sram_bitcell
Xbit_r4_c9 WL[4] BL[9] BLB[9] VDD GND sram_bitcell
Xbit_r4_c10 WL[4] BL[10] BLB[10] VDD GND sram_bitcell
Xbit_r4_c11 WL[4] BL[11] BLB[11] VDD GND sram_bitcell
Xbit_r4_c12 WL[4] BL[12] BLB[12] VDD GND sram_bitcell
Xbit_r4_c13 WL[4] BL[13] BLB[13] VDD GND sram_bitcell
Xbit_r4_c14 WL[4] BL[14] BLB[14] VDD GND sram_bitcell
Xbit_r4_c15 WL[4] BL[15] BLB[15] VDD GND sram_bitcell
Xbit_r4_c16 WL[4] BL[16] BLB[16] VDD GND sram_bitcell
Xbit_r4_c17 WL[4] BL[17] BLB[17] VDD GND sram_bitcell
Xbit_r4_c18 WL[4] BL[18] BLB[18] VDD GND sram_bitcell
Xbit_r4_c19 WL[4] BL[19] BLB[19] VDD GND sram_bitcell
Xbit_r4_c20 WL[4] BL[20] BLB[20] VDD GND sram_bitcell
Xbit_r4_c21 WL[4] BL[21] BLB[21] VDD GND sram_bitcell
Xbit_r4_c22 WL[4] BL[22] BLB[22] VDD GND sram_bitcell
Xbit_r4_c23 WL[4] BL[23] BLB[23] VDD GND sram_bitcell
Xbit_r4_c24 WL[4] BL[24] BLB[24] VDD GND sram_bitcell
Xbit_r4_c25 WL[4] BL[25] BLB[25] VDD GND sram_bitcell
Xbit_r4_c26 WL[4] BL[26] BLB[26] VDD GND sram_bitcell
Xbit_r4_c27 WL[4] BL[27] BLB[27] VDD GND sram_bitcell
Xbit_r4_c28 WL[4] BL[28] BLB[28] VDD GND sram_bitcell
Xbit_r4_c29 WL[4] BL[29] BLB[29] VDD GND sram_bitcell
Xbit_r4_c30 WL[4] BL[30] BLB[30] VDD GND sram_bitcell
Xbit_r4_c31 WL[4] BL[31] BLB[31] VDD GND sram_bitcell
Xbit_r5_c0 WL[5] BL[0] BLB[0] VDD GND sram_bitcell
Xbit_r5_c1 WL[5] BL[1] BLB[1] VDD GND sram_bitcell
Xbit_r5_c2 WL[5] BL[2] BLB[2] VDD GND sram_bitcell
Xbit_r5_c3 WL[5] BL[3] BLB[3] VDD GND sram_bitcell
Xbit_r5_c4 WL[5] BL[4] BLB[4] VDD GND sram_bitcell
Xbit_r5_c5 WL[5] BL[5] BLB[5] VDD GND sram_bitcell
Xbit_r5_c6 WL[5] BL[6] BLB[6] VDD GND sram_bitcell
Xbit_r5_c7 WL[5] BL[7] BLB[7] VDD GND sram_bitcell
Xbit_r5_c8 WL[5] BL[8] BLB[8] VDD GND sram_bitcell
Xbit_r5_c9 WL[5] BL[9] BLB[9] VDD GND sram_bitcell
Xbit_r5_c10 WL[5] BL[10] BLB[10] VDD GND sram_bitcell
Xbit_r5_c11 WL[5] BL[11] BLB[11] VDD GND sram_bitcell
Xbit_r5_c12 WL[5] BL[12] BLB[12] VDD GND sram_bitcell
Xbit_r5_c13 WL[5] BL[13] BLB[13] VDD GND sram_bitcell
Xbit_r5_c14 WL[5] BL[14] BLB[14] VDD GND sram_bitcell
Xbit_r5_c15 WL[5] BL[15] BLB[15] VDD GND sram_bitcell
Xbit_r5_c16 WL[5] BL[16] BLB[16] VDD GND sram_bitcell
Xbit_r5_c17 WL[5] BL[17] BLB[17] VDD GND sram_bitcell
Xbit_r5_c18 WL[5] BL[18] BLB[18] VDD GND sram_bitcell
Xbit_r5_c19 WL[5] BL[19] BLB[19] VDD GND sram_bitcell
Xbit_r5_c20 WL[5] BL[20] BLB[20] VDD GND sram_bitcell
Xbit_r5_c21 WL[5] BL[21] BLB[21] VDD GND sram_bitcell
Xbit_r5_c22 WL[5] BL[22] BLB[22] VDD GND sram_bitcell
Xbit_r5_c23 WL[5] BL[23] BLB[23] VDD GND sram_bitcell
Xbit_r5_c24 WL[5] BL[24] BLB[24] VDD GND sram_bitcell
Xbit_r5_c25 WL[5] BL[25] BLB[25] VDD GND sram_bitcell
Xbit_r5_c26 WL[5] BL[26] BLB[26] VDD GND sram_bitcell
Xbit_r5_c27 WL[5] BL[27] BLB[27] VDD GND sram_bitcell
Xbit_r5_c28 WL[5] BL[28] BLB[28] VDD GND sram_bitcell
Xbit_r5_c29 WL[5] BL[29] BLB[29] VDD GND sram_bitcell
Xbit_r5_c30 WL[5] BL[30] BLB[30] VDD GND sram_bitcell
Xbit_r5_c31 WL[5] BL[31] BLB[31] VDD GND sram_bitcell
Xbit_r6_c0 WL[6] BL[0] BLB[0] VDD GND sram_bitcell
Xbit_r6_c1 WL[6] BL[1] BLB[1] VDD GND sram_bitcell
Xbit_r6_c2 WL[6] BL[2] BLB[2] VDD GND sram_bitcell
Xbit_r6_c3 WL[6] BL[3] BLB[3] VDD GND sram_bitcell
Xbit_r6_c4 WL[6] BL[4] BLB[4] VDD GND sram_bitcell
Xbit_r6_c5 WL[6] BL[5] BLB[5] VDD GND sram_bitcell
Xbit_r6_c6 WL[6] BL[6] BLB[6] VDD GND sram_bitcell
Xbit_r6_c7 WL[6] BL[7] BLB[7] VDD GND sram_bitcell
Xbit_r6_c8 WL[6] BL[8] BLB[8] VDD GND sram_bitcell
Xbit_r6_c9 WL[6] BL[9] BLB[9] VDD GND sram_bitcell
Xbit_r6_c10 WL[6] BL[10] BLB[10] VDD GND sram_bitcell
Xbit_r6_c11 WL[6] BL[11] BLB[11] VDD GND sram_bitcell
Xbit_r6_c12 WL[6] BL[12] BLB[12] VDD GND sram_bitcell
Xbit_r6_c13 WL[6] BL[13] BLB[13] VDD GND sram_bitcell
Xbit_r6_c14 WL[6] BL[14] BLB[14] VDD GND sram_bitcell
Xbit_r6_c15 WL[6] BL[15] BLB[15] VDD GND sram_bitcell
Xbit_r6_c16 WL[6] BL[16] BLB[16] VDD GND sram_bitcell
Xbit_r6_c17 WL[6] BL[17] BLB[17] VDD GND sram_bitcell
Xbit_r6_c18 WL[6] BL[18] BLB[18] VDD GND sram_bitcell
Xbit_r6_c19 WL[6] BL[19] BLB[19] VDD GND sram_bitcell
Xbit_r6_c20 WL[6] BL[20] BLB[20] VDD GND sram_bitcell
Xbit_r6_c21 WL[6] BL[21] BLB[21] VDD GND sram_bitcell
Xbit_r6_c22 WL[6] BL[22] BLB[22] VDD GND sram_bitcell
Xbit_r6_c23 WL[6] BL[23] BLB[23] VDD GND sram_bitcell
Xbit_r6_c24 WL[6] BL[24] BLB[24] VDD GND sram_bitcell
Xbit_r6_c25 WL[6] BL[25] BLB[25] VDD GND sram_bitcell
Xbit_r6_c26 WL[6] BL[26] BLB[26] VDD GND sram_bitcell
Xbit_r6_c27 WL[6] BL[27] BLB[27] VDD GND sram_bitcell
Xbit_r6_c28 WL[6] BL[28] BLB[28] VDD GND sram_bitcell
Xbit_r6_c29 WL[6] BL[29] BLB[29] VDD GND sram_bitcell
Xbit_r6_c30 WL[6] BL[30] BLB[30] VDD GND sram_bitcell
Xbit_r6_c31 WL[6] BL[31] BLB[31] VDD GND sram_bitcell
Xbit_r7_c0 WL[7] BL[0] BLB[0] VDD GND sram_bitcell
Xbit_r7_c1 WL[7] BL[1] BLB[1] VDD GND sram_bitcell
Xbit_r7_c2 WL[7] BL[2] BLB[2] VDD GND sram_bitcell
Xbit_r7_c3 WL[7] BL[3] BLB[3] VDD GND sram_bitcell
Xbit_r7_c4 WL[7] BL[4] BLB[4] VDD GND sram_bitcell
Xbit_r7_c5 WL[7] BL[5] BLB[5] VDD GND sram_bitcell
Xbit_r7_c6 WL[7] BL[6] BLB[6] VDD GND sram_bitcell
Xbit_r7_c7 WL[7] BL[7] BLB[7] VDD GND sram_bitcell
Xbit_r7_c8 WL[7] BL[8] BLB[8] VDD GND sram_bitcell
Xbit_r7_c9 WL[7] BL[9] BLB[9] VDD GND sram_bitcell
Xbit_r7_c10 WL[7] BL[10] BLB[10] VDD GND sram_bitcell
Xbit_r7_c11 WL[7] BL[11] BLB[11] VDD GND sram_bitcell
Xbit_r7_c12 WL[7] BL[12] BLB[12] VDD GND sram_bitcell
Xbit_r7_c13 WL[7] BL[13] BLB[13] VDD GND sram_bitcell
Xbit_r7_c14 WL[7] BL[14] BLB[14] VDD GND sram_bitcell
Xbit_r7_c15 WL[7] BL[15] BLB[15] VDD GND sram_bitcell
Xbit_r7_c16 WL[7] BL[16] BLB[16] VDD GND sram_bitcell
Xbit_r7_c17 WL[7] BL[17] BLB[17] VDD GND sram_bitcell
Xbit_r7_c18 WL[7] BL[18] BLB[18] VDD GND sram_bitcell
Xbit_r7_c19 WL[7] BL[19] BLB[19] VDD GND sram_bitcell
Xbit_r7_c20 WL[7] BL[20] BLB[20] VDD GND sram_bitcell
Xbit_r7_c21 WL[7] BL[21] BLB[21] VDD GND sram_bitcell
Xbit_r7_c22 WL[7] BL[22] BLB[22] VDD GND sram_bitcell
Xbit_r7_c23 WL[7] BL[23] BLB[23] VDD GND sram_bitcell
Xbit_r7_c24 WL[7] BL[24] BLB[24] VDD GND sram_bitcell
Xbit_r7_c25 WL[7] BL[25] BLB[25] VDD GND sram_bitcell
Xbit_r7_c26 WL[7] BL[26] BLB[26] VDD GND sram_bitcell
Xbit_r7_c27 WL[7] BL[27] BLB[27] VDD GND sram_bitcell
Xbit_r7_c28 WL[7] BL[28] BLB[28] VDD GND sram_bitcell
Xbit_r7_c29 WL[7] BL[29] BLB[29] VDD GND sram_bitcell
Xbit_r7_c30 WL[7] BL[30] BLB[30] VDD GND sram_bitcell
Xbit_r7_c31 WL[7] BL[31] BLB[31] VDD GND sram_bitcell
Xbit_r8_c0 WL[8] BL[0] BLB[0] VDD GND sram_bitcell
Xbit_r8_c1 WL[8] BL[1] BLB[1] VDD GND sram_bitcell
Xbit_r8_c2 WL[8] BL[2] BLB[2] VDD GND sram_bitcell
Xbit_r8_c3 WL[8] BL[3] BLB[3] VDD GND sram_bitcell
Xbit_r8_c4 WL[8] BL[4] BLB[4] VDD GND sram_bitcell
Xbit_r8_c5 WL[8] BL[5] BLB[5] VDD GND sram_bitcell
Xbit_r8_c6 WL[8] BL[6] BLB[6] VDD GND sram_bitcell
Xbit_r8_c7 WL[8] BL[7] BLB[7] VDD GND sram_bitcell
Xbit_r8_c8 WL[8] BL[8] BLB[8] VDD GND sram_bitcell
Xbit_r8_c9 WL[8] BL[9] BLB[9] VDD GND sram_bitcell
Xbit_r8_c10 WL[8] BL[10] BLB[10] VDD GND sram_bitcell
Xbit_r8_c11 WL[8] BL[11] BLB[11] VDD GND sram_bitcell
Xbit_r8_c12 WL[8] BL[12] BLB[12] VDD GND sram_bitcell
Xbit_r8_c13 WL[8] BL[13] BLB[13] VDD GND sram_bitcell
Xbit_r8_c14 WL[8] BL[14] BLB[14] VDD GND sram_bitcell
Xbit_r8_c15 WL[8] BL[15] BLB[15] VDD GND sram_bitcell
Xbit_r8_c16 WL[8] BL[16] BLB[16] VDD GND sram_bitcell
Xbit_r8_c17 WL[8] BL[17] BLB[17] VDD GND sram_bitcell
Xbit_r8_c18 WL[8] BL[18] BLB[18] VDD GND sram_bitcell
Xbit_r8_c19 WL[8] BL[19] BLB[19] VDD GND sram_bitcell
Xbit_r8_c20 WL[8] BL[20] BLB[20] VDD GND sram_bitcell
Xbit_r8_c21 WL[8] BL[21] BLB[21] VDD GND sram_bitcell
Xbit_r8_c22 WL[8] BL[22] BLB[22] VDD GND sram_bitcell
Xbit_r8_c23 WL[8] BL[23] BLB[23] VDD GND sram_bitcell
Xbit_r8_c24 WL[8] BL[24] BLB[24] VDD GND sram_bitcell
Xbit_r8_c25 WL[8] BL[25] BLB[25] VDD GND sram_bitcell
Xbit_r8_c26 WL[8] BL[26] BLB[26] VDD GND sram_bitcell
Xbit_r8_c27 WL[8] BL[27] BLB[27] VDD GND sram_bitcell
Xbit_r8_c28 WL[8] BL[28] BLB[28] VDD GND sram_bitcell
Xbit_r8_c29 WL[8] BL[29] BLB[29] VDD GND sram_bitcell
Xbit_r8_c30 WL[8] BL[30] BLB[30] VDD GND sram_bitcell
Xbit_r8_c31 WL[8] BL[31] BLB[31] VDD GND sram_bitcell
Xbit_r9_c0 WL[9] BL[0] BLB[0] VDD GND sram_bitcell
Xbit_r9_c1 WL[9] BL[1] BLB[1] VDD GND sram_bitcell
Xbit_r9_c2 WL[9] BL[2] BLB[2] VDD GND sram_bitcell
Xbit_r9_c3 WL[9] BL[3] BLB[3] VDD GND sram_bitcell
Xbit_r9_c4 WL[9] BL[4] BLB[4] VDD GND sram_bitcell
Xbit_r9_c5 WL[9] BL[5] BLB[5] VDD GND sram_bitcell
Xbit_r9_c6 WL[9] BL[6] BLB[6] VDD GND sram_bitcell
Xbit_r9_c7 WL[9] BL[7] BLB[7] VDD GND sram_bitcell
Xbit_r9_c8 WL[9] BL[8] BLB[8] VDD GND sram_bitcell
Xbit_r9_c9 WL[9] BL[9] BLB[9] VDD GND sram_bitcell
Xbit_r9_c10 WL[9] BL[10] BLB[10] VDD GND sram_bitcell
Xbit_r9_c11 WL[9] BL[11] BLB[11] VDD GND sram_bitcell
Xbit_r9_c12 WL[9] BL[12] BLB[12] VDD GND sram_bitcell
Xbit_r9_c13 WL[9] BL[13] BLB[13] VDD GND sram_bitcell
Xbit_r9_c14 WL[9] BL[14] BLB[14] VDD GND sram_bitcell
Xbit_r9_c15 WL[9] BL[15] BLB[15] VDD GND sram_bitcell
Xbit_r9_c16 WL[9] BL[16] BLB[16] VDD GND sram_bitcell
Xbit_r9_c17 WL[9] BL[17] BLB[17] VDD GND sram_bitcell
Xbit_r9_c18 WL[9] BL[18] BLB[18] VDD GND sram_bitcell
Xbit_r9_c19 WL[9] BL[19] BLB[19] VDD GND sram_bitcell
Xbit_r9_c20 WL[9] BL[20] BLB[20] VDD GND sram_bitcell
Xbit_r9_c21 WL[9] BL[21] BLB[21] VDD GND sram_bitcell
Xbit_r9_c22 WL[9] BL[22] BLB[22] VDD GND sram_bitcell
Xbit_r9_c23 WL[9] BL[23] BLB[23] VDD GND sram_bitcell
Xbit_r9_c24 WL[9] BL[24] BLB[24] VDD GND sram_bitcell
Xbit_r9_c25 WL[9] BL[25] BLB[25] VDD GND sram_bitcell
Xbit_r9_c26 WL[9] BL[26] BLB[26] VDD GND sram_bitcell
Xbit_r9_c27 WL[9] BL[27] BLB[27] VDD GND sram_bitcell
Xbit_r9_c28 WL[9] BL[28] BLB[28] VDD GND sram_bitcell
Xbit_r9_c29 WL[9] BL[29] BLB[29] VDD GND sram_bitcell
Xbit_r9_c30 WL[9] BL[30] BLB[30] VDD GND sram_bitcell
Xbit_r9_c31 WL[9] BL[31] BLB[31] VDD GND sram_bitcell
Xbit_r10_c0 WL[10] BL[0] BLB[0] VDD GND sram_bitcell
Xbit_r10_c1 WL[10] BL[1] BLB[1] VDD GND sram_bitcell
Xbit_r10_c2 WL[10] BL[2] BLB[2] VDD GND sram_bitcell
Xbit_r10_c3 WL[10] BL[3] BLB[3] VDD GND sram_bitcell
Xbit_r10_c4 WL[10] BL[4] BLB[4] VDD GND sram_bitcell
Xbit_r10_c5 WL[10] BL[5] BLB[5] VDD GND sram_bitcell
Xbit_r10_c6 WL[10] BL[6] BLB[6] VDD GND sram_bitcell
Xbit_r10_c7 WL[10] BL[7] BLB[7] VDD GND sram_bitcell
Xbit_r10_c8 WL[10] BL[8] BLB[8] VDD GND sram_bitcell
Xbit_r10_c9 WL[10] BL[9] BLB[9] VDD GND sram_bitcell
Xbit_r10_c10 WL[10] BL[10] BLB[10] VDD GND sram_bitcell
Xbit_r10_c11 WL[10] BL[11] BLB[11] VDD GND sram_bitcell
Xbit_r10_c12 WL[10] BL[12] BLB[12] VDD GND sram_bitcell
Xbit_r10_c13 WL[10] BL[13] BLB[13] VDD GND sram_bitcell
Xbit_r10_c14 WL[10] BL[14] BLB[14] VDD GND sram_bitcell
Xbit_r10_c15 WL[10] BL[15] BLB[15] VDD GND sram_bitcell
Xbit_r10_c16 WL[10] BL[16] BLB[16] VDD GND sram_bitcell
Xbit_r10_c17 WL[10] BL[17] BLB[17] VDD GND sram_bitcell
Xbit_r10_c18 WL[10] BL[18] BLB[18] VDD GND sram_bitcell
Xbit_r10_c19 WL[10] BL[19] BLB[19] VDD GND sram_bitcell
Xbit_r10_c20 WL[10] BL[20] BLB[20] VDD GND sram_bitcell
Xbit_r10_c21 WL[10] BL[21] BLB[21] VDD GND sram_bitcell
Xbit_r10_c22 WL[10] BL[22] BLB[22] VDD GND sram_bitcell
Xbit_r10_c23 WL[10] BL[23] BLB[23] VDD GND sram_bitcell
Xbit_r10_c24 WL[10] BL[24] BLB[24] VDD GND sram_bitcell
Xbit_r10_c25 WL[10] BL[25] BLB[25] VDD GND sram_bitcell
Xbit_r10_c26 WL[10] BL[26] BLB[26] VDD GND sram_bitcell
Xbit_r10_c27 WL[10] BL[27] BLB[27] VDD GND sram_bitcell
Xbit_r10_c28 WL[10] BL[28] BLB[28] VDD GND sram_bitcell
Xbit_r10_c29 WL[10] BL[29] BLB[29] VDD GND sram_bitcell
Xbit_r10_c30 WL[10] BL[30] BLB[30] VDD GND sram_bitcell
Xbit_r10_c31 WL[10] BL[31] BLB[31] VDD GND sram_bitcell
Xbit_r11_c0 WL[11] BL[0] BLB[0] VDD GND sram_bitcell
Xbit_r11_c1 WL[11] BL[1] BLB[1] VDD GND sram_bitcell
Xbit_r11_c2 WL[11] BL[2] BLB[2] VDD GND sram_bitcell
Xbit_r11_c3 WL[11] BL[3] BLB[3] VDD GND sram_bitcell
Xbit_r11_c4 WL[11] BL[4] BLB[4] VDD GND sram_bitcell
Xbit_r11_c5 WL[11] BL[5] BLB[5] VDD GND sram_bitcell
Xbit_r11_c6 WL[11] BL[6] BLB[6] VDD GND sram_bitcell
Xbit_r11_c7 WL[11] BL[7] BLB[7] VDD GND sram_bitcell
Xbit_r11_c8 WL[11] BL[8] BLB[8] VDD GND sram_bitcell
Xbit_r11_c9 WL[11] BL[9] BLB[9] VDD GND sram_bitcell
Xbit_r11_c10 WL[11] BL[10] BLB[10] VDD GND sram_bitcell
Xbit_r11_c11 WL[11] BL[11] BLB[11] VDD GND sram_bitcell
Xbit_r11_c12 WL[11] BL[12] BLB[12] VDD GND sram_bitcell
Xbit_r11_c13 WL[11] BL[13] BLB[13] VDD GND sram_bitcell
Xbit_r11_c14 WL[11] BL[14] BLB[14] VDD GND sram_bitcell
Xbit_r11_c15 WL[11] BL[15] BLB[15] VDD GND sram_bitcell
Xbit_r11_c16 WL[11] BL[16] BLB[16] VDD GND sram_bitcell
Xbit_r11_c17 WL[11] BL[17] BLB[17] VDD GND sram_bitcell
Xbit_r11_c18 WL[11] BL[18] BLB[18] VDD GND sram_bitcell
Xbit_r11_c19 WL[11] BL[19] BLB[19] VDD GND sram_bitcell
Xbit_r11_c20 WL[11] BL[20] BLB[20] VDD GND sram_bitcell
Xbit_r11_c21 WL[11] BL[21] BLB[21] VDD GND sram_bitcell
Xbit_r11_c22 WL[11] BL[22] BLB[22] VDD GND sram_bitcell
Xbit_r11_c23 WL[11] BL[23] BLB[23] VDD GND sram_bitcell
Xbit_r11_c24 WL[11] BL[24] BLB[24] VDD GND sram_bitcell
Xbit_r11_c25 WL[11] BL[25] BLB[25] VDD GND sram_bitcell
Xbit_r11_c26 WL[11] BL[26] BLB[26] VDD GND sram_bitcell
Xbit_r11_c27 WL[11] BL[27] BLB[27] VDD GND sram_bitcell
Xbit_r11_c28 WL[11] BL[28] BLB[28] VDD GND sram_bitcell
Xbit_r11_c29 WL[11] BL[29] BLB[29] VDD GND sram_bitcell
Xbit_r11_c30 WL[11] BL[30] BLB[30] VDD GND sram_bitcell
Xbit_r11_c31 WL[11] BL[31] BLB[31] VDD GND sram_bitcell
Xbit_r12_c0 WL[12] BL[0] BLB[0] VDD GND sram_bitcell
Xbit_r12_c1 WL[12] BL[1] BLB[1] VDD GND sram_bitcell
Xbit_r12_c2 WL[12] BL[2] BLB[2] VDD GND sram_bitcell
Xbit_r12_c3 WL[12] BL[3] BLB[3] VDD GND sram_bitcell
Xbit_r12_c4 WL[12] BL[4] BLB[4] VDD GND sram_bitcell
Xbit_r12_c5 WL[12] BL[5] BLB[5] VDD GND sram_bitcell
Xbit_r12_c6 WL[12] BL[6] BLB[6] VDD GND sram_bitcell
Xbit_r12_c7 WL[12] BL[7] BLB[7] VDD GND sram_bitcell
Xbit_r12_c8 WL[12] BL[8] BLB[8] VDD GND sram_bitcell
Xbit_r12_c9 WL[12] BL[9] BLB[9] VDD GND sram_bitcell
Xbit_r12_c10 WL[12] BL[10] BLB[10] VDD GND sram_bitcell
Xbit_r12_c11 WL[12] BL[11] BLB[11] VDD GND sram_bitcell
Xbit_r12_c12 WL[12] BL[12] BLB[12] VDD GND sram_bitcell
Xbit_r12_c13 WL[12] BL[13] BLB[13] VDD GND sram_bitcell
Xbit_r12_c14 WL[12] BL[14] BLB[14] VDD GND sram_bitcell
Xbit_r12_c15 WL[12] BL[15] BLB[15] VDD GND sram_bitcell
Xbit_r12_c16 WL[12] BL[16] BLB[16] VDD GND sram_bitcell
Xbit_r12_c17 WL[12] BL[17] BLB[17] VDD GND sram_bitcell
Xbit_r12_c18 WL[12] BL[18] BLB[18] VDD GND sram_bitcell
Xbit_r12_c19 WL[12] BL[19] BLB[19] VDD GND sram_bitcell
Xbit_r12_c20 WL[12] BL[20] BLB[20] VDD GND sram_bitcell
Xbit_r12_c21 WL[12] BL[21] BLB[21] VDD GND sram_bitcell
Xbit_r12_c22 WL[12] BL[22] BLB[22] VDD GND sram_bitcell
Xbit_r12_c23 WL[12] BL[23] BLB[23] VDD GND sram_bitcell
Xbit_r12_c24 WL[12] BL[24] BLB[24] VDD GND sram_bitcell
Xbit_r12_c25 WL[12] BL[25] BLB[25] VDD GND sram_bitcell
Xbit_r12_c26 WL[12] BL[26] BLB[26] VDD GND sram_bitcell
Xbit_r12_c27 WL[12] BL[27] BLB[27] VDD GND sram_bitcell
Xbit_r12_c28 WL[12] BL[28] BLB[28] VDD GND sram_bitcell
Xbit_r12_c29 WL[12] BL[29] BLB[29] VDD GND sram_bitcell
Xbit_r12_c30 WL[12] BL[30] BLB[30] VDD GND sram_bitcell
Xbit_r12_c31 WL[12] BL[31] BLB[31] VDD GND sram_bitcell
Xbit_r13_c0 WL[13] BL[0] BLB[0] VDD GND sram_bitcell
Xbit_r13_c1 WL[13] BL[1] BLB[1] VDD GND sram_bitcell
Xbit_r13_c2 WL[13] BL[2] BLB[2] VDD GND sram_bitcell
Xbit_r13_c3 WL[13] BL[3] BLB[3] VDD GND sram_bitcell
Xbit_r13_c4 WL[13] BL[4] BLB[4] VDD GND sram_bitcell
Xbit_r13_c5 WL[13] BL[5] BLB[5] VDD GND sram_bitcell
Xbit_r13_c6 WL[13] BL[6] BLB[6] VDD GND sram_bitcell
Xbit_r13_c7 WL[13] BL[7] BLB[7] VDD GND sram_bitcell
Xbit_r13_c8 WL[13] BL[8] BLB[8] VDD GND sram_bitcell
Xbit_r13_c9 WL[13] BL[9] BLB[9] VDD GND sram_bitcell
Xbit_r13_c10 WL[13] BL[10] BLB[10] VDD GND sram_bitcell
Xbit_r13_c11 WL[13] BL[11] BLB[11] VDD GND sram_bitcell
Xbit_r13_c12 WL[13] BL[12] BLB[12] VDD GND sram_bitcell
Xbit_r13_c13 WL[13] BL[13] BLB[13] VDD GND sram_bitcell
Xbit_r13_c14 WL[13] BL[14] BLB[14] VDD GND sram_bitcell
Xbit_r13_c15 WL[13] BL[15] BLB[15] VDD GND sram_bitcell
Xbit_r13_c16 WL[13] BL[16] BLB[16] VDD GND sram_bitcell
Xbit_r13_c17 WL[13] BL[17] BLB[17] VDD GND sram_bitcell
Xbit_r13_c18 WL[13] BL[18] BLB[18] VDD GND sram_bitcell
Xbit_r13_c19 WL[13] BL[19] BLB[19] VDD GND sram_bitcell
Xbit_r13_c20 WL[13] BL[20] BLB[20] VDD GND sram_bitcell
Xbit_r13_c21 WL[13] BL[21] BLB[21] VDD GND sram_bitcell
Xbit_r13_c22 WL[13] BL[22] BLB[22] VDD GND sram_bitcell
Xbit_r13_c23 WL[13] BL[23] BLB[23] VDD GND sram_bitcell
Xbit_r13_c24 WL[13] BL[24] BLB[24] VDD GND sram_bitcell
Xbit_r13_c25 WL[13] BL[25] BLB[25] VDD GND sram_bitcell
Xbit_r13_c26 WL[13] BL[26] BLB[26] VDD GND sram_bitcell
Xbit_r13_c27 WL[13] BL[27] BLB[27] VDD GND sram_bitcell
Xbit_r13_c28 WL[13] BL[28] BLB[28] VDD GND sram_bitcell
Xbit_r13_c29 WL[13] BL[29] BLB[29] VDD GND sram_bitcell
Xbit_r13_c30 WL[13] BL[30] BLB[30] VDD GND sram_bitcell
Xbit_r13_c31 WL[13] BL[31] BLB[31] VDD GND sram_bitcell
Xbit_r14_c0 WL[14] BL[0] BLB[0] VDD GND sram_bitcell
Xbit_r14_c1 WL[14] BL[1] BLB[1] VDD GND sram_bitcell
Xbit_r14_c2 WL[14] BL[2] BLB[2] VDD GND sram_bitcell
Xbit_r14_c3 WL[14] BL[3] BLB[3] VDD GND sram_bitcell
Xbit_r14_c4 WL[14] BL[4] BLB[4] VDD GND sram_bitcell
Xbit_r14_c5 WL[14] BL[5] BLB[5] VDD GND sram_bitcell
Xbit_r14_c6 WL[14] BL[6] BLB[6] VDD GND sram_bitcell
Xbit_r14_c7 WL[14] BL[7] BLB[7] VDD GND sram_bitcell
Xbit_r14_c8 WL[14] BL[8] BLB[8] VDD GND sram_bitcell
Xbit_r14_c9 WL[14] BL[9] BLB[9] VDD GND sram_bitcell
Xbit_r14_c10 WL[14] BL[10] BLB[10] VDD GND sram_bitcell
Xbit_r14_c11 WL[14] BL[11] BLB[11] VDD GND sram_bitcell
Xbit_r14_c12 WL[14] BL[12] BLB[12] VDD GND sram_bitcell
Xbit_r14_c13 WL[14] BL[13] BLB[13] VDD GND sram_bitcell
Xbit_r14_c14 WL[14] BL[14] BLB[14] VDD GND sram_bitcell
Xbit_r14_c15 WL[14] BL[15] BLB[15] VDD GND sram_bitcell
Xbit_r14_c16 WL[14] BL[16] BLB[16] VDD GND sram_bitcell
Xbit_r14_c17 WL[14] BL[17] BLB[17] VDD GND sram_bitcell
Xbit_r14_c18 WL[14] BL[18] BLB[18] VDD GND sram_bitcell
Xbit_r14_c19 WL[14] BL[19] BLB[19] VDD GND sram_bitcell
Xbit_r14_c20 WL[14] BL[20] BLB[20] VDD GND sram_bitcell
Xbit_r14_c21 WL[14] BL[21] BLB[21] VDD GND sram_bitcell
Xbit_r14_c22 WL[14] BL[22] BLB[22] VDD GND sram_bitcell
Xbit_r14_c23 WL[14] BL[23] BLB[23] VDD GND sram_bitcell
Xbit_r14_c24 WL[14] BL[24] BLB[24] VDD GND sram_bitcell
Xbit_r14_c25 WL[14] BL[25] BLB[25] VDD GND sram_bitcell
Xbit_r14_c26 WL[14] BL[26] BLB[26] VDD GND sram_bitcell
Xbit_r14_c27 WL[14] BL[27] BLB[27] VDD GND sram_bitcell
Xbit_r14_c28 WL[14] BL[28] BLB[28] VDD GND sram_bitcell
Xbit_r14_c29 WL[14] BL[29] BLB[29] VDD GND sram_bitcell
Xbit_r14_c30 WL[14] BL[30] BLB[30] VDD GND sram_bitcell
Xbit_r14_c31 WL[14] BL[31] BLB[31] VDD GND sram_bitcell
Xbit_r15_c0 WL[15] BL[0] BLB[0] VDD GND sram_bitcell
Xbit_r15_c1 WL[15] BL[1] BLB[1] VDD GND sram_bitcell
Xbit_r15_c2 WL[15] BL[2] BLB[2] VDD GND sram_bitcell
Xbit_r15_c3 WL[15] BL[3] BLB[3] VDD GND sram_bitcell
Xbit_r15_c4 WL[15] BL[4] BLB[4] VDD GND sram_bitcell
Xbit_r15_c5 WL[15] BL[5] BLB[5] VDD GND sram_bitcell
Xbit_r15_c6 WL[15] BL[6] BLB[6] VDD GND sram_bitcell
Xbit_r15_c7 WL[15] BL[7] BLB[7] VDD GND sram_bitcell
Xbit_r15_c8 WL[15] BL[8] BLB[8] VDD GND sram_bitcell
Xbit_r15_c9 WL[15] BL[9] BLB[9] VDD GND sram_bitcell
Xbit_r15_c10 WL[15] BL[10] BLB[10] VDD GND sram_bitcell
Xbit_r15_c11 WL[15] BL[11] BLB[11] VDD GND sram_bitcell
Xbit_r15_c12 WL[15] BL[12] BLB[12] VDD GND sram_bitcell
Xbit_r15_c13 WL[15] BL[13] BLB[13] VDD GND sram_bitcell
Xbit_r15_c14 WL[15] BL[14] BLB[14] VDD GND sram_bitcell
Xbit_r15_c15 WL[15] BL[15] BLB[15] VDD GND sram_bitcell
Xbit_r15_c16 WL[15] BL[16] BLB[16] VDD GND sram_bitcell
Xbit_r15_c17 WL[15] BL[17] BLB[17] VDD GND sram_bitcell
Xbit_r15_c18 WL[15] BL[18] BLB[18] VDD GND sram_bitcell
Xbit_r15_c19 WL[15] BL[19] BLB[19] VDD GND sram_bitcell
Xbit_r15_c20 WL[15] BL[20] BLB[20] VDD GND sram_bitcell
Xbit_r15_c21 WL[15] BL[21] BLB[21] VDD GND sram_bitcell
Xbit_r15_c22 WL[15] BL[22] BLB[22] VDD GND sram_bitcell
Xbit_r15_c23 WL[15] BL[23] BLB[23] VDD GND sram_bitcell
Xbit_r15_c24 WL[15] BL[24] BLB[24] VDD GND sram_bitcell
Xbit_r15_c25 WL[15] BL[25] BLB[25] VDD GND sram_bitcell
Xbit_r15_c26 WL[15] BL[26] BLB[26] VDD GND sram_bitcell
Xbit_r15_c27 WL[15] BL[27] BLB[27] VDD GND sram_bitcell
Xbit_r15_c28 WL[15] BL[28] BLB[28] VDD GND sram_bitcell
Xbit_r15_c29 WL[15] BL[29] BLB[29] VDD GND sram_bitcell
Xbit_r15_c30 WL[15] BL[30] BLB[30] VDD GND sram_bitcell
Xbit_r15_c31 WL[15] BL[31] BLB[31] VDD GND sram_bitcell
Xbit_r16_c0 WL[16] BL[0] BLB[0] VDD GND sram_bitcell
Xbit_r16_c1 WL[16] BL[1] BLB[1] VDD GND sram_bitcell
Xbit_r16_c2 WL[16] BL[2] BLB[2] VDD GND sram_bitcell
Xbit_r16_c3 WL[16] BL[3] BLB[3] VDD GND sram_bitcell
Xbit_r16_c4 WL[16] BL[4] BLB[4] VDD GND sram_bitcell
Xbit_r16_c5 WL[16] BL[5] BLB[5] VDD GND sram_bitcell
Xbit_r16_c6 WL[16] BL[6] BLB[6] VDD GND sram_bitcell
Xbit_r16_c7 WL[16] BL[7] BLB[7] VDD GND sram_bitcell
Xbit_r16_c8 WL[16] BL[8] BLB[8] VDD GND sram_bitcell
Xbit_r16_c9 WL[16] BL[9] BLB[9] VDD GND sram_bitcell
Xbit_r16_c10 WL[16] BL[10] BLB[10] VDD GND sram_bitcell
Xbit_r16_c11 WL[16] BL[11] BLB[11] VDD GND sram_bitcell
Xbit_r16_c12 WL[16] BL[12] BLB[12] VDD GND sram_bitcell
Xbit_r16_c13 WL[16] BL[13] BLB[13] VDD GND sram_bitcell
Xbit_r16_c14 WL[16] BL[14] BLB[14] VDD GND sram_bitcell
Xbit_r16_c15 WL[16] BL[15] BLB[15] VDD GND sram_bitcell
Xbit_r16_c16 WL[16] BL[16] BLB[16] VDD GND sram_bitcell
Xbit_r16_c17 WL[16] BL[17] BLB[17] VDD GND sram_bitcell
Xbit_r16_c18 WL[16] BL[18] BLB[18] VDD GND sram_bitcell
Xbit_r16_c19 WL[16] BL[19] BLB[19] VDD GND sram_bitcell
Xbit_r16_c20 WL[16] BL[20] BLB[20] VDD GND sram_bitcell
Xbit_r16_c21 WL[16] BL[21] BLB[21] VDD GND sram_bitcell
Xbit_r16_c22 WL[16] BL[22] BLB[22] VDD GND sram_bitcell
Xbit_r16_c23 WL[16] BL[23] BLB[23] VDD GND sram_bitcell
Xbit_r16_c24 WL[16] BL[24] BLB[24] VDD GND sram_bitcell
Xbit_r16_c25 WL[16] BL[25] BLB[25] VDD GND sram_bitcell
Xbit_r16_c26 WL[16] BL[26] BLB[26] VDD GND sram_bitcell
Xbit_r16_c27 WL[16] BL[27] BLB[27] VDD GND sram_bitcell
Xbit_r16_c28 WL[16] BL[28] BLB[28] VDD GND sram_bitcell
Xbit_r16_c29 WL[16] BL[29] BLB[29] VDD GND sram_bitcell
Xbit_r16_c30 WL[16] BL[30] BLB[30] VDD GND sram_bitcell
Xbit_r16_c31 WL[16] BL[31] BLB[31] VDD GND sram_bitcell
Xbit_r17_c0 WL[17] BL[0] BLB[0] VDD GND sram_bitcell
Xbit_r17_c1 WL[17] BL[1] BLB[1] VDD GND sram_bitcell
Xbit_r17_c2 WL[17] BL[2] BLB[2] VDD GND sram_bitcell
Xbit_r17_c3 WL[17] BL[3] BLB[3] VDD GND sram_bitcell
Xbit_r17_c4 WL[17] BL[4] BLB[4] VDD GND sram_bitcell
Xbit_r17_c5 WL[17] BL[5] BLB[5] VDD GND sram_bitcell
Xbit_r17_c6 WL[17] BL[6] BLB[6] VDD GND sram_bitcell
Xbit_r17_c7 WL[17] BL[7] BLB[7] VDD GND sram_bitcell
Xbit_r17_c8 WL[17] BL[8] BLB[8] VDD GND sram_bitcell
Xbit_r17_c9 WL[17] BL[9] BLB[9] VDD GND sram_bitcell
Xbit_r17_c10 WL[17] BL[10] BLB[10] VDD GND sram_bitcell
Xbit_r17_c11 WL[17] BL[11] BLB[11] VDD GND sram_bitcell
Xbit_r17_c12 WL[17] BL[12] BLB[12] VDD GND sram_bitcell
Xbit_r17_c13 WL[17] BL[13] BLB[13] VDD GND sram_bitcell
Xbit_r17_c14 WL[17] BL[14] BLB[14] VDD GND sram_bitcell
Xbit_r17_c15 WL[17] BL[15] BLB[15] VDD GND sram_bitcell
Xbit_r17_c16 WL[17] BL[16] BLB[16] VDD GND sram_bitcell
Xbit_r17_c17 WL[17] BL[17] BLB[17] VDD GND sram_bitcell
Xbit_r17_c18 WL[17] BL[18] BLB[18] VDD GND sram_bitcell
Xbit_r17_c19 WL[17] BL[19] BLB[19] VDD GND sram_bitcell
Xbit_r17_c20 WL[17] BL[20] BLB[20] VDD GND sram_bitcell
Xbit_r17_c21 WL[17] BL[21] BLB[21] VDD GND sram_bitcell
Xbit_r17_c22 WL[17] BL[22] BLB[22] VDD GND sram_bitcell
Xbit_r17_c23 WL[17] BL[23] BLB[23] VDD GND sram_bitcell
Xbit_r17_c24 WL[17] BL[24] BLB[24] VDD GND sram_bitcell
Xbit_r17_c25 WL[17] BL[25] BLB[25] VDD GND sram_bitcell
Xbit_r17_c26 WL[17] BL[26] BLB[26] VDD GND sram_bitcell
Xbit_r17_c27 WL[17] BL[27] BLB[27] VDD GND sram_bitcell
Xbit_r17_c28 WL[17] BL[28] BLB[28] VDD GND sram_bitcell
Xbit_r17_c29 WL[17] BL[29] BLB[29] VDD GND sram_bitcell
Xbit_r17_c30 WL[17] BL[30] BLB[30] VDD GND sram_bitcell
Xbit_r17_c31 WL[17] BL[31] BLB[31] VDD GND sram_bitcell
Xbit_r18_c0 WL[18] BL[0] BLB[0] VDD GND sram_bitcell
Xbit_r18_c1 WL[18] BL[1] BLB[1] VDD GND sram_bitcell
Xbit_r18_c2 WL[18] BL[2] BLB[2] VDD GND sram_bitcell
Xbit_r18_c3 WL[18] BL[3] BLB[3] VDD GND sram_bitcell
Xbit_r18_c4 WL[18] BL[4] BLB[4] VDD GND sram_bitcell
Xbit_r18_c5 WL[18] BL[5] BLB[5] VDD GND sram_bitcell
Xbit_r18_c6 WL[18] BL[6] BLB[6] VDD GND sram_bitcell
Xbit_r18_c7 WL[18] BL[7] BLB[7] VDD GND sram_bitcell
Xbit_r18_c8 WL[18] BL[8] BLB[8] VDD GND sram_bitcell
Xbit_r18_c9 WL[18] BL[9] BLB[9] VDD GND sram_bitcell
Xbit_r18_c10 WL[18] BL[10] BLB[10] VDD GND sram_bitcell
Xbit_r18_c11 WL[18] BL[11] BLB[11] VDD GND sram_bitcell
Xbit_r18_c12 WL[18] BL[12] BLB[12] VDD GND sram_bitcell
Xbit_r18_c13 WL[18] BL[13] BLB[13] VDD GND sram_bitcell
Xbit_r18_c14 WL[18] BL[14] BLB[14] VDD GND sram_bitcell
Xbit_r18_c15 WL[18] BL[15] BLB[15] VDD GND sram_bitcell
Xbit_r18_c16 WL[18] BL[16] BLB[16] VDD GND sram_bitcell
Xbit_r18_c17 WL[18] BL[17] BLB[17] VDD GND sram_bitcell
Xbit_r18_c18 WL[18] BL[18] BLB[18] VDD GND sram_bitcell
Xbit_r18_c19 WL[18] BL[19] BLB[19] VDD GND sram_bitcell
Xbit_r18_c20 WL[18] BL[20] BLB[20] VDD GND sram_bitcell
Xbit_r18_c21 WL[18] BL[21] BLB[21] VDD GND sram_bitcell
Xbit_r18_c22 WL[18] BL[22] BLB[22] VDD GND sram_bitcell
Xbit_r18_c23 WL[18] BL[23] BLB[23] VDD GND sram_bitcell
Xbit_r18_c24 WL[18] BL[24] BLB[24] VDD GND sram_bitcell
Xbit_r18_c25 WL[18] BL[25] BLB[25] VDD GND sram_bitcell
Xbit_r18_c26 WL[18] BL[26] BLB[26] VDD GND sram_bitcell
Xbit_r18_c27 WL[18] BL[27] BLB[27] VDD GND sram_bitcell
Xbit_r18_c28 WL[18] BL[28] BLB[28] VDD GND sram_bitcell
Xbit_r18_c29 WL[18] BL[29] BLB[29] VDD GND sram_bitcell
Xbit_r18_c30 WL[18] BL[30] BLB[30] VDD GND sram_bitcell
Xbit_r18_c31 WL[18] BL[31] BLB[31] VDD GND sram_bitcell
Xbit_r19_c0 WL[19] BL[0] BLB[0] VDD GND sram_bitcell
Xbit_r19_c1 WL[19] BL[1] BLB[1] VDD GND sram_bitcell
Xbit_r19_c2 WL[19] BL[2] BLB[2] VDD GND sram_bitcell
Xbit_r19_c3 WL[19] BL[3] BLB[3] VDD GND sram_bitcell
Xbit_r19_c4 WL[19] BL[4] BLB[4] VDD GND sram_bitcell
Xbit_r19_c5 WL[19] BL[5] BLB[5] VDD GND sram_bitcell
Xbit_r19_c6 WL[19] BL[6] BLB[6] VDD GND sram_bitcell
Xbit_r19_c7 WL[19] BL[7] BLB[7] VDD GND sram_bitcell
Xbit_r19_c8 WL[19] BL[8] BLB[8] VDD GND sram_bitcell
Xbit_r19_c9 WL[19] BL[9] BLB[9] VDD GND sram_bitcell
Xbit_r19_c10 WL[19] BL[10] BLB[10] VDD GND sram_bitcell
Xbit_r19_c11 WL[19] BL[11] BLB[11] VDD GND sram_bitcell
Xbit_r19_c12 WL[19] BL[12] BLB[12] VDD GND sram_bitcell
Xbit_r19_c13 WL[19] BL[13] BLB[13] VDD GND sram_bitcell
Xbit_r19_c14 WL[19] BL[14] BLB[14] VDD GND sram_bitcell
Xbit_r19_c15 WL[19] BL[15] BLB[15] VDD GND sram_bitcell
Xbit_r19_c16 WL[19] BL[16] BLB[16] VDD GND sram_bitcell
Xbit_r19_c17 WL[19] BL[17] BLB[17] VDD GND sram_bitcell
Xbit_r19_c18 WL[19] BL[18] BLB[18] VDD GND sram_bitcell
Xbit_r19_c19 WL[19] BL[19] BLB[19] VDD GND sram_bitcell
Xbit_r19_c20 WL[19] BL[20] BLB[20] VDD GND sram_bitcell
Xbit_r19_c21 WL[19] BL[21] BLB[21] VDD GND sram_bitcell
Xbit_r19_c22 WL[19] BL[22] BLB[22] VDD GND sram_bitcell
Xbit_r19_c23 WL[19] BL[23] BLB[23] VDD GND sram_bitcell
Xbit_r19_c24 WL[19] BL[24] BLB[24] VDD GND sram_bitcell
Xbit_r19_c25 WL[19] BL[25] BLB[25] VDD GND sram_bitcell
Xbit_r19_c26 WL[19] BL[26] BLB[26] VDD GND sram_bitcell
Xbit_r19_c27 WL[19] BL[27] BLB[27] VDD GND sram_bitcell
Xbit_r19_c28 WL[19] BL[28] BLB[28] VDD GND sram_bitcell
Xbit_r19_c29 WL[19] BL[29] BLB[29] VDD GND sram_bitcell
Xbit_r19_c30 WL[19] BL[30] BLB[30] VDD GND sram_bitcell
Xbit_r19_c31 WL[19] BL[31] BLB[31] VDD GND sram_bitcell
Xbit_r20_c0 WL[20] BL[0] BLB[0] VDD GND sram_bitcell
Xbit_r20_c1 WL[20] BL[1] BLB[1] VDD GND sram_bitcell
Xbit_r20_c2 WL[20] BL[2] BLB[2] VDD GND sram_bitcell
Xbit_r20_c3 WL[20] BL[3] BLB[3] VDD GND sram_bitcell
Xbit_r20_c4 WL[20] BL[4] BLB[4] VDD GND sram_bitcell
Xbit_r20_c5 WL[20] BL[5] BLB[5] VDD GND sram_bitcell
Xbit_r20_c6 WL[20] BL[6] BLB[6] VDD GND sram_bitcell
Xbit_r20_c7 WL[20] BL[7] BLB[7] VDD GND sram_bitcell
Xbit_r20_c8 WL[20] BL[8] BLB[8] VDD GND sram_bitcell
Xbit_r20_c9 WL[20] BL[9] BLB[9] VDD GND sram_bitcell
Xbit_r20_c10 WL[20] BL[10] BLB[10] VDD GND sram_bitcell
Xbit_r20_c11 WL[20] BL[11] BLB[11] VDD GND sram_bitcell
Xbit_r20_c12 WL[20] BL[12] BLB[12] VDD GND sram_bitcell
Xbit_r20_c13 WL[20] BL[13] BLB[13] VDD GND sram_bitcell
Xbit_r20_c14 WL[20] BL[14] BLB[14] VDD GND sram_bitcell
Xbit_r20_c15 WL[20] BL[15] BLB[15] VDD GND sram_bitcell
Xbit_r20_c16 WL[20] BL[16] BLB[16] VDD GND sram_bitcell
Xbit_r20_c17 WL[20] BL[17] BLB[17] VDD GND sram_bitcell
Xbit_r20_c18 WL[20] BL[18] BLB[18] VDD GND sram_bitcell
Xbit_r20_c19 WL[20] BL[19] BLB[19] VDD GND sram_bitcell
Xbit_r20_c20 WL[20] BL[20] BLB[20] VDD GND sram_bitcell
Xbit_r20_c21 WL[20] BL[21] BLB[21] VDD GND sram_bitcell
Xbit_r20_c22 WL[20] BL[22] BLB[22] VDD GND sram_bitcell
Xbit_r20_c23 WL[20] BL[23] BLB[23] VDD GND sram_bitcell
Xbit_r20_c24 WL[20] BL[24] BLB[24] VDD GND sram_bitcell
Xbit_r20_c25 WL[20] BL[25] BLB[25] VDD GND sram_bitcell
Xbit_r20_c26 WL[20] BL[26] BLB[26] VDD GND sram_bitcell
Xbit_r20_c27 WL[20] BL[27] BLB[27] VDD GND sram_bitcell
Xbit_r20_c28 WL[20] BL[28] BLB[28] VDD GND sram_bitcell
Xbit_r20_c29 WL[20] BL[29] BLB[29] VDD GND sram_bitcell
Xbit_r20_c30 WL[20] BL[30] BLB[30] VDD GND sram_bitcell
Xbit_r20_c31 WL[20] BL[31] BLB[31] VDD GND sram_bitcell
Xbit_r21_c0 WL[21] BL[0] BLB[0] VDD GND sram_bitcell
Xbit_r21_c1 WL[21] BL[1] BLB[1] VDD GND sram_bitcell
Xbit_r21_c2 WL[21] BL[2] BLB[2] VDD GND sram_bitcell
Xbit_r21_c3 WL[21] BL[3] BLB[3] VDD GND sram_bitcell
Xbit_r21_c4 WL[21] BL[4] BLB[4] VDD GND sram_bitcell
Xbit_r21_c5 WL[21] BL[5] BLB[5] VDD GND sram_bitcell
Xbit_r21_c6 WL[21] BL[6] BLB[6] VDD GND sram_bitcell
Xbit_r21_c7 WL[21] BL[7] BLB[7] VDD GND sram_bitcell
Xbit_r21_c8 WL[21] BL[8] BLB[8] VDD GND sram_bitcell
Xbit_r21_c9 WL[21] BL[9] BLB[9] VDD GND sram_bitcell
Xbit_r21_c10 WL[21] BL[10] BLB[10] VDD GND sram_bitcell
Xbit_r21_c11 WL[21] BL[11] BLB[11] VDD GND sram_bitcell
Xbit_r21_c12 WL[21] BL[12] BLB[12] VDD GND sram_bitcell
Xbit_r21_c13 WL[21] BL[13] BLB[13] VDD GND sram_bitcell
Xbit_r21_c14 WL[21] BL[14] BLB[14] VDD GND sram_bitcell
Xbit_r21_c15 WL[21] BL[15] BLB[15] VDD GND sram_bitcell
Xbit_r21_c16 WL[21] BL[16] BLB[16] VDD GND sram_bitcell
Xbit_r21_c17 WL[21] BL[17] BLB[17] VDD GND sram_bitcell
Xbit_r21_c18 WL[21] BL[18] BLB[18] VDD GND sram_bitcell
Xbit_r21_c19 WL[21] BL[19] BLB[19] VDD GND sram_bitcell
Xbit_r21_c20 WL[21] BL[20] BLB[20] VDD GND sram_bitcell
Xbit_r21_c21 WL[21] BL[21] BLB[21] VDD GND sram_bitcell
Xbit_r21_c22 WL[21] BL[22] BLB[22] VDD GND sram_bitcell
Xbit_r21_c23 WL[21] BL[23] BLB[23] VDD GND sram_bitcell
Xbit_r21_c24 WL[21] BL[24] BLB[24] VDD GND sram_bitcell
Xbit_r21_c25 WL[21] BL[25] BLB[25] VDD GND sram_bitcell
Xbit_r21_c26 WL[21] BL[26] BLB[26] VDD GND sram_bitcell
Xbit_r21_c27 WL[21] BL[27] BLB[27] VDD GND sram_bitcell
Xbit_r21_c28 WL[21] BL[28] BLB[28] VDD GND sram_bitcell
Xbit_r21_c29 WL[21] BL[29] BLB[29] VDD GND sram_bitcell
Xbit_r21_c30 WL[21] BL[30] BLB[30] VDD GND sram_bitcell
Xbit_r21_c31 WL[21] BL[31] BLB[31] VDD GND sram_bitcell
Xbit_r22_c0 WL[22] BL[0] BLB[0] VDD GND sram_bitcell
Xbit_r22_c1 WL[22] BL[1] BLB[1] VDD GND sram_bitcell
Xbit_r22_c2 WL[22] BL[2] BLB[2] VDD GND sram_bitcell
Xbit_r22_c3 WL[22] BL[3] BLB[3] VDD GND sram_bitcell
Xbit_r22_c4 WL[22] BL[4] BLB[4] VDD GND sram_bitcell
Xbit_r22_c5 WL[22] BL[5] BLB[5] VDD GND sram_bitcell
Xbit_r22_c6 WL[22] BL[6] BLB[6] VDD GND sram_bitcell
Xbit_r22_c7 WL[22] BL[7] BLB[7] VDD GND sram_bitcell
Xbit_r22_c8 WL[22] BL[8] BLB[8] VDD GND sram_bitcell
Xbit_r22_c9 WL[22] BL[9] BLB[9] VDD GND sram_bitcell
Xbit_r22_c10 WL[22] BL[10] BLB[10] VDD GND sram_bitcell
Xbit_r22_c11 WL[22] BL[11] BLB[11] VDD GND sram_bitcell
Xbit_r22_c12 WL[22] BL[12] BLB[12] VDD GND sram_bitcell
Xbit_r22_c13 WL[22] BL[13] BLB[13] VDD GND sram_bitcell
Xbit_r22_c14 WL[22] BL[14] BLB[14] VDD GND sram_bitcell
Xbit_r22_c15 WL[22] BL[15] BLB[15] VDD GND sram_bitcell
Xbit_r22_c16 WL[22] BL[16] BLB[16] VDD GND sram_bitcell
Xbit_r22_c17 WL[22] BL[17] BLB[17] VDD GND sram_bitcell
Xbit_r22_c18 WL[22] BL[18] BLB[18] VDD GND sram_bitcell
Xbit_r22_c19 WL[22] BL[19] BLB[19] VDD GND sram_bitcell
Xbit_r22_c20 WL[22] BL[20] BLB[20] VDD GND sram_bitcell
Xbit_r22_c21 WL[22] BL[21] BLB[21] VDD GND sram_bitcell
Xbit_r22_c22 WL[22] BL[22] BLB[22] VDD GND sram_bitcell
Xbit_r22_c23 WL[22] BL[23] BLB[23] VDD GND sram_bitcell
Xbit_r22_c24 WL[22] BL[24] BLB[24] VDD GND sram_bitcell
Xbit_r22_c25 WL[22] BL[25] BLB[25] VDD GND sram_bitcell
Xbit_r22_c26 WL[22] BL[26] BLB[26] VDD GND sram_bitcell
Xbit_r22_c27 WL[22] BL[27] BLB[27] VDD GND sram_bitcell
Xbit_r22_c28 WL[22] BL[28] BLB[28] VDD GND sram_bitcell
Xbit_r22_c29 WL[22] BL[29] BLB[29] VDD GND sram_bitcell
Xbit_r22_c30 WL[22] BL[30] BLB[30] VDD GND sram_bitcell
Xbit_r22_c31 WL[22] BL[31] BLB[31] VDD GND sram_bitcell
Xbit_r23_c0 WL[23] BL[0] BLB[0] VDD GND sram_bitcell
Xbit_r23_c1 WL[23] BL[1] BLB[1] VDD GND sram_bitcell
Xbit_r23_c2 WL[23] BL[2] BLB[2] VDD GND sram_bitcell
Xbit_r23_c3 WL[23] BL[3] BLB[3] VDD GND sram_bitcell
Xbit_r23_c4 WL[23] BL[4] BLB[4] VDD GND sram_bitcell
Xbit_r23_c5 WL[23] BL[5] BLB[5] VDD GND sram_bitcell
Xbit_r23_c6 WL[23] BL[6] BLB[6] VDD GND sram_bitcell
Xbit_r23_c7 WL[23] BL[7] BLB[7] VDD GND sram_bitcell
Xbit_r23_c8 WL[23] BL[8] BLB[8] VDD GND sram_bitcell
Xbit_r23_c9 WL[23] BL[9] BLB[9] VDD GND sram_bitcell
Xbit_r23_c10 WL[23] BL[10] BLB[10] VDD GND sram_bitcell
Xbit_r23_c11 WL[23] BL[11] BLB[11] VDD GND sram_bitcell
Xbit_r23_c12 WL[23] BL[12] BLB[12] VDD GND sram_bitcell
Xbit_r23_c13 WL[23] BL[13] BLB[13] VDD GND sram_bitcell
Xbit_r23_c14 WL[23] BL[14] BLB[14] VDD GND sram_bitcell
Xbit_r23_c15 WL[23] BL[15] BLB[15] VDD GND sram_bitcell
Xbit_r23_c16 WL[23] BL[16] BLB[16] VDD GND sram_bitcell
Xbit_r23_c17 WL[23] BL[17] BLB[17] VDD GND sram_bitcell
Xbit_r23_c18 WL[23] BL[18] BLB[18] VDD GND sram_bitcell
Xbit_r23_c19 WL[23] BL[19] BLB[19] VDD GND sram_bitcell
Xbit_r23_c20 WL[23] BL[20] BLB[20] VDD GND sram_bitcell
Xbit_r23_c21 WL[23] BL[21] BLB[21] VDD GND sram_bitcell
Xbit_r23_c22 WL[23] BL[22] BLB[22] VDD GND sram_bitcell
Xbit_r23_c23 WL[23] BL[23] BLB[23] VDD GND sram_bitcell
Xbit_r23_c24 WL[23] BL[24] BLB[24] VDD GND sram_bitcell
Xbit_r23_c25 WL[23] BL[25] BLB[25] VDD GND sram_bitcell
Xbit_r23_c26 WL[23] BL[26] BLB[26] VDD GND sram_bitcell
Xbit_r23_c27 WL[23] BL[27] BLB[27] VDD GND sram_bitcell
Xbit_r23_c28 WL[23] BL[28] BLB[28] VDD GND sram_bitcell
Xbit_r23_c29 WL[23] BL[29] BLB[29] VDD GND sram_bitcell
Xbit_r23_c30 WL[23] BL[30] BLB[30] VDD GND sram_bitcell
Xbit_r23_c31 WL[23] BL[31] BLB[31] VDD GND sram_bitcell
Xbit_r24_c0 WL[24] BL[0] BLB[0] VDD GND sram_bitcell
Xbit_r24_c1 WL[24] BL[1] BLB[1] VDD GND sram_bitcell
Xbit_r24_c2 WL[24] BL[2] BLB[2] VDD GND sram_bitcell
Xbit_r24_c3 WL[24] BL[3] BLB[3] VDD GND sram_bitcell
Xbit_r24_c4 WL[24] BL[4] BLB[4] VDD GND sram_bitcell
Xbit_r24_c5 WL[24] BL[5] BLB[5] VDD GND sram_bitcell
Xbit_r24_c6 WL[24] BL[6] BLB[6] VDD GND sram_bitcell
Xbit_r24_c7 WL[24] BL[7] BLB[7] VDD GND sram_bitcell
Xbit_r24_c8 WL[24] BL[8] BLB[8] VDD GND sram_bitcell
Xbit_r24_c9 WL[24] BL[9] BLB[9] VDD GND sram_bitcell
Xbit_r24_c10 WL[24] BL[10] BLB[10] VDD GND sram_bitcell
Xbit_r24_c11 WL[24] BL[11] BLB[11] VDD GND sram_bitcell
Xbit_r24_c12 WL[24] BL[12] BLB[12] VDD GND sram_bitcell
Xbit_r24_c13 WL[24] BL[13] BLB[13] VDD GND sram_bitcell
Xbit_r24_c14 WL[24] BL[14] BLB[14] VDD GND sram_bitcell
Xbit_r24_c15 WL[24] BL[15] BLB[15] VDD GND sram_bitcell
Xbit_r24_c16 WL[24] BL[16] BLB[16] VDD GND sram_bitcell
Xbit_r24_c17 WL[24] BL[17] BLB[17] VDD GND sram_bitcell
Xbit_r24_c18 WL[24] BL[18] BLB[18] VDD GND sram_bitcell
Xbit_r24_c19 WL[24] BL[19] BLB[19] VDD GND sram_bitcell
Xbit_r24_c20 WL[24] BL[20] BLB[20] VDD GND sram_bitcell
Xbit_r24_c21 WL[24] BL[21] BLB[21] VDD GND sram_bitcell
Xbit_r24_c22 WL[24] BL[22] BLB[22] VDD GND sram_bitcell
Xbit_r24_c23 WL[24] BL[23] BLB[23] VDD GND sram_bitcell
Xbit_r24_c24 WL[24] BL[24] BLB[24] VDD GND sram_bitcell
Xbit_r24_c25 WL[24] BL[25] BLB[25] VDD GND sram_bitcell
Xbit_r24_c26 WL[24] BL[26] BLB[26] VDD GND sram_bitcell
Xbit_r24_c27 WL[24] BL[27] BLB[27] VDD GND sram_bitcell
Xbit_r24_c28 WL[24] BL[28] BLB[28] VDD GND sram_bitcell
Xbit_r24_c29 WL[24] BL[29] BLB[29] VDD GND sram_bitcell
Xbit_r24_c30 WL[24] BL[30] BLB[30] VDD GND sram_bitcell
Xbit_r24_c31 WL[24] BL[31] BLB[31] VDD GND sram_bitcell
Xbit_r25_c0 WL[25] BL[0] BLB[0] VDD GND sram_bitcell
Xbit_r25_c1 WL[25] BL[1] BLB[1] VDD GND sram_bitcell
Xbit_r25_c2 WL[25] BL[2] BLB[2] VDD GND sram_bitcell
Xbit_r25_c3 WL[25] BL[3] BLB[3] VDD GND sram_bitcell
Xbit_r25_c4 WL[25] BL[4] BLB[4] VDD GND sram_bitcell
Xbit_r25_c5 WL[25] BL[5] BLB[5] VDD GND sram_bitcell
Xbit_r25_c6 WL[25] BL[6] BLB[6] VDD GND sram_bitcell
Xbit_r25_c7 WL[25] BL[7] BLB[7] VDD GND sram_bitcell
Xbit_r25_c8 WL[25] BL[8] BLB[8] VDD GND sram_bitcell
Xbit_r25_c9 WL[25] BL[9] BLB[9] VDD GND sram_bitcell
Xbit_r25_c10 WL[25] BL[10] BLB[10] VDD GND sram_bitcell
Xbit_r25_c11 WL[25] BL[11] BLB[11] VDD GND sram_bitcell
Xbit_r25_c12 WL[25] BL[12] BLB[12] VDD GND sram_bitcell
Xbit_r25_c13 WL[25] BL[13] BLB[13] VDD GND sram_bitcell
Xbit_r25_c14 WL[25] BL[14] BLB[14] VDD GND sram_bitcell
Xbit_r25_c15 WL[25] BL[15] BLB[15] VDD GND sram_bitcell
Xbit_r25_c16 WL[25] BL[16] BLB[16] VDD GND sram_bitcell
Xbit_r25_c17 WL[25] BL[17] BLB[17] VDD GND sram_bitcell
Xbit_r25_c18 WL[25] BL[18] BLB[18] VDD GND sram_bitcell
Xbit_r25_c19 WL[25] BL[19] BLB[19] VDD GND sram_bitcell
Xbit_r25_c20 WL[25] BL[20] BLB[20] VDD GND sram_bitcell
Xbit_r25_c21 WL[25] BL[21] BLB[21] VDD GND sram_bitcell
Xbit_r25_c22 WL[25] BL[22] BLB[22] VDD GND sram_bitcell
Xbit_r25_c23 WL[25] BL[23] BLB[23] VDD GND sram_bitcell
Xbit_r25_c24 WL[25] BL[24] BLB[24] VDD GND sram_bitcell
Xbit_r25_c25 WL[25] BL[25] BLB[25] VDD GND sram_bitcell
Xbit_r25_c26 WL[25] BL[26] BLB[26] VDD GND sram_bitcell
Xbit_r25_c27 WL[25] BL[27] BLB[27] VDD GND sram_bitcell
Xbit_r25_c28 WL[25] BL[28] BLB[28] VDD GND sram_bitcell
Xbit_r25_c29 WL[25] BL[29] BLB[29] VDD GND sram_bitcell
Xbit_r25_c30 WL[25] BL[30] BLB[30] VDD GND sram_bitcell
Xbit_r25_c31 WL[25] BL[31] BLB[31] VDD GND sram_bitcell
Xbit_r26_c0 WL[26] BL[0] BLB[0] VDD GND sram_bitcell
Xbit_r26_c1 WL[26] BL[1] BLB[1] VDD GND sram_bitcell
Xbit_r26_c2 WL[26] BL[2] BLB[2] VDD GND sram_bitcell
Xbit_r26_c3 WL[26] BL[3] BLB[3] VDD GND sram_bitcell
Xbit_r26_c4 WL[26] BL[4] BLB[4] VDD GND sram_bitcell
Xbit_r26_c5 WL[26] BL[5] BLB[5] VDD GND sram_bitcell
Xbit_r26_c6 WL[26] BL[6] BLB[6] VDD GND sram_bitcell
Xbit_r26_c7 WL[26] BL[7] BLB[7] VDD GND sram_bitcell
Xbit_r26_c8 WL[26] BL[8] BLB[8] VDD GND sram_bitcell
Xbit_r26_c9 WL[26] BL[9] BLB[9] VDD GND sram_bitcell
Xbit_r26_c10 WL[26] BL[10] BLB[10] VDD GND sram_bitcell
Xbit_r26_c11 WL[26] BL[11] BLB[11] VDD GND sram_bitcell
Xbit_r26_c12 WL[26] BL[12] BLB[12] VDD GND sram_bitcell
Xbit_r26_c13 WL[26] BL[13] BLB[13] VDD GND sram_bitcell
Xbit_r26_c14 WL[26] BL[14] BLB[14] VDD GND sram_bitcell
Xbit_r26_c15 WL[26] BL[15] BLB[15] VDD GND sram_bitcell
Xbit_r26_c16 WL[26] BL[16] BLB[16] VDD GND sram_bitcell
Xbit_r26_c17 WL[26] BL[17] BLB[17] VDD GND sram_bitcell
Xbit_r26_c18 WL[26] BL[18] BLB[18] VDD GND sram_bitcell
Xbit_r26_c19 WL[26] BL[19] BLB[19] VDD GND sram_bitcell
Xbit_r26_c20 WL[26] BL[20] BLB[20] VDD GND sram_bitcell
Xbit_r26_c21 WL[26] BL[21] BLB[21] VDD GND sram_bitcell
Xbit_r26_c22 WL[26] BL[22] BLB[22] VDD GND sram_bitcell
Xbit_r26_c23 WL[26] BL[23] BLB[23] VDD GND sram_bitcell
Xbit_r26_c24 WL[26] BL[24] BLB[24] VDD GND sram_bitcell
Xbit_r26_c25 WL[26] BL[25] BLB[25] VDD GND sram_bitcell
Xbit_r26_c26 WL[26] BL[26] BLB[26] VDD GND sram_bitcell
Xbit_r26_c27 WL[26] BL[27] BLB[27] VDD GND sram_bitcell
Xbit_r26_c28 WL[26] BL[28] BLB[28] VDD GND sram_bitcell
Xbit_r26_c29 WL[26] BL[29] BLB[29] VDD GND sram_bitcell
Xbit_r26_c30 WL[26] BL[30] BLB[30] VDD GND sram_bitcell
Xbit_r26_c31 WL[26] BL[31] BLB[31] VDD GND sram_bitcell
Xbit_r27_c0 WL[27] BL[0] BLB[0] VDD GND sram_bitcell
Xbit_r27_c1 WL[27] BL[1] BLB[1] VDD GND sram_bitcell
Xbit_r27_c2 WL[27] BL[2] BLB[2] VDD GND sram_bitcell
Xbit_r27_c3 WL[27] BL[3] BLB[3] VDD GND sram_bitcell
Xbit_r27_c4 WL[27] BL[4] BLB[4] VDD GND sram_bitcell
Xbit_r27_c5 WL[27] BL[5] BLB[5] VDD GND sram_bitcell
Xbit_r27_c6 WL[27] BL[6] BLB[6] VDD GND sram_bitcell
Xbit_r27_c7 WL[27] BL[7] BLB[7] VDD GND sram_bitcell
Xbit_r27_c8 WL[27] BL[8] BLB[8] VDD GND sram_bitcell
Xbit_r27_c9 WL[27] BL[9] BLB[9] VDD GND sram_bitcell
Xbit_r27_c10 WL[27] BL[10] BLB[10] VDD GND sram_bitcell
Xbit_r27_c11 WL[27] BL[11] BLB[11] VDD GND sram_bitcell
Xbit_r27_c12 WL[27] BL[12] BLB[12] VDD GND sram_bitcell
Xbit_r27_c13 WL[27] BL[13] BLB[13] VDD GND sram_bitcell
Xbit_r27_c14 WL[27] BL[14] BLB[14] VDD GND sram_bitcell
Xbit_r27_c15 WL[27] BL[15] BLB[15] VDD GND sram_bitcell
Xbit_r27_c16 WL[27] BL[16] BLB[16] VDD GND sram_bitcell
Xbit_r27_c17 WL[27] BL[17] BLB[17] VDD GND sram_bitcell
Xbit_r27_c18 WL[27] BL[18] BLB[18] VDD GND sram_bitcell
Xbit_r27_c19 WL[27] BL[19] BLB[19] VDD GND sram_bitcell
Xbit_r27_c20 WL[27] BL[20] BLB[20] VDD GND sram_bitcell
Xbit_r27_c21 WL[27] BL[21] BLB[21] VDD GND sram_bitcell
Xbit_r27_c22 WL[27] BL[22] BLB[22] VDD GND sram_bitcell
Xbit_r27_c23 WL[27] BL[23] BLB[23] VDD GND sram_bitcell
Xbit_r27_c24 WL[27] BL[24] BLB[24] VDD GND sram_bitcell
Xbit_r27_c25 WL[27] BL[25] BLB[25] VDD GND sram_bitcell
Xbit_r27_c26 WL[27] BL[26] BLB[26] VDD GND sram_bitcell
Xbit_r27_c27 WL[27] BL[27] BLB[27] VDD GND sram_bitcell
Xbit_r27_c28 WL[27] BL[28] BLB[28] VDD GND sram_bitcell
Xbit_r27_c29 WL[27] BL[29] BLB[29] VDD GND sram_bitcell
Xbit_r27_c30 WL[27] BL[30] BLB[30] VDD GND sram_bitcell
Xbit_r27_c31 WL[27] BL[31] BLB[31] VDD GND sram_bitcell
Xbit_r28_c0 WL[28] BL[0] BLB[0] VDD GND sram_bitcell
Xbit_r28_c1 WL[28] BL[1] BLB[1] VDD GND sram_bitcell
Xbit_r28_c2 WL[28] BL[2] BLB[2] VDD GND sram_bitcell
Xbit_r28_c3 WL[28] BL[3] BLB[3] VDD GND sram_bitcell
Xbit_r28_c4 WL[28] BL[4] BLB[4] VDD GND sram_bitcell
Xbit_r28_c5 WL[28] BL[5] BLB[5] VDD GND sram_bitcell
Xbit_r28_c6 WL[28] BL[6] BLB[6] VDD GND sram_bitcell
Xbit_r28_c7 WL[28] BL[7] BLB[7] VDD GND sram_bitcell
Xbit_r28_c8 WL[28] BL[8] BLB[8] VDD GND sram_bitcell
Xbit_r28_c9 WL[28] BL[9] BLB[9] VDD GND sram_bitcell
Xbit_r28_c10 WL[28] BL[10] BLB[10] VDD GND sram_bitcell
Xbit_r28_c11 WL[28] BL[11] BLB[11] VDD GND sram_bitcell
Xbit_r28_c12 WL[28] BL[12] BLB[12] VDD GND sram_bitcell
Xbit_r28_c13 WL[28] BL[13] BLB[13] VDD GND sram_bitcell
Xbit_r28_c14 WL[28] BL[14] BLB[14] VDD GND sram_bitcell
Xbit_r28_c15 WL[28] BL[15] BLB[15] VDD GND sram_bitcell
Xbit_r28_c16 WL[28] BL[16] BLB[16] VDD GND sram_bitcell
Xbit_r28_c17 WL[28] BL[17] BLB[17] VDD GND sram_bitcell
Xbit_r28_c18 WL[28] BL[18] BLB[18] VDD GND sram_bitcell
Xbit_r28_c19 WL[28] BL[19] BLB[19] VDD GND sram_bitcell
Xbit_r28_c20 WL[28] BL[20] BLB[20] VDD GND sram_bitcell
Xbit_r28_c21 WL[28] BL[21] BLB[21] VDD GND sram_bitcell
Xbit_r28_c22 WL[28] BL[22] BLB[22] VDD GND sram_bitcell
Xbit_r28_c23 WL[28] BL[23] BLB[23] VDD GND sram_bitcell
Xbit_r28_c24 WL[28] BL[24] BLB[24] VDD GND sram_bitcell
Xbit_r28_c25 WL[28] BL[25] BLB[25] VDD GND sram_bitcell
Xbit_r28_c26 WL[28] BL[26] BLB[26] VDD GND sram_bitcell
Xbit_r28_c27 WL[28] BL[27] BLB[27] VDD GND sram_bitcell
Xbit_r28_c28 WL[28] BL[28] BLB[28] VDD GND sram_bitcell
Xbit_r28_c29 WL[28] BL[29] BLB[29] VDD GND sram_bitcell
Xbit_r28_c30 WL[28] BL[30] BLB[30] VDD GND sram_bitcell
Xbit_r28_c31 WL[28] BL[31] BLB[31] VDD GND sram_bitcell
Xbit_r29_c0 WL[29] BL[0] BLB[0] VDD GND sram_bitcell
Xbit_r29_c1 WL[29] BL[1] BLB[1] VDD GND sram_bitcell
Xbit_r29_c2 WL[29] BL[2] BLB[2] VDD GND sram_bitcell
Xbit_r29_c3 WL[29] BL[3] BLB[3] VDD GND sram_bitcell
Xbit_r29_c4 WL[29] BL[4] BLB[4] VDD GND sram_bitcell
Xbit_r29_c5 WL[29] BL[5] BLB[5] VDD GND sram_bitcell
Xbit_r29_c6 WL[29] BL[6] BLB[6] VDD GND sram_bitcell
Xbit_r29_c7 WL[29] BL[7] BLB[7] VDD GND sram_bitcell
Xbit_r29_c8 WL[29] BL[8] BLB[8] VDD GND sram_bitcell
Xbit_r29_c9 WL[29] BL[9] BLB[9] VDD GND sram_bitcell
Xbit_r29_c10 WL[29] BL[10] BLB[10] VDD GND sram_bitcell
Xbit_r29_c11 WL[29] BL[11] BLB[11] VDD GND sram_bitcell
Xbit_r29_c12 WL[29] BL[12] BLB[12] VDD GND sram_bitcell
Xbit_r29_c13 WL[29] BL[13] BLB[13] VDD GND sram_bitcell
Xbit_r29_c14 WL[29] BL[14] BLB[14] VDD GND sram_bitcell
Xbit_r29_c15 WL[29] BL[15] BLB[15] VDD GND sram_bitcell
Xbit_r29_c16 WL[29] BL[16] BLB[16] VDD GND sram_bitcell
Xbit_r29_c17 WL[29] BL[17] BLB[17] VDD GND sram_bitcell
Xbit_r29_c18 WL[29] BL[18] BLB[18] VDD GND sram_bitcell
Xbit_r29_c19 WL[29] BL[19] BLB[19] VDD GND sram_bitcell
Xbit_r29_c20 WL[29] BL[20] BLB[20] VDD GND sram_bitcell
Xbit_r29_c21 WL[29] BL[21] BLB[21] VDD GND sram_bitcell
Xbit_r29_c22 WL[29] BL[22] BLB[22] VDD GND sram_bitcell
Xbit_r29_c23 WL[29] BL[23] BLB[23] VDD GND sram_bitcell
Xbit_r29_c24 WL[29] BL[24] BLB[24] VDD GND sram_bitcell
Xbit_r29_c25 WL[29] BL[25] BLB[25] VDD GND sram_bitcell
Xbit_r29_c26 WL[29] BL[26] BLB[26] VDD GND sram_bitcell
Xbit_r29_c27 WL[29] BL[27] BLB[27] VDD GND sram_bitcell
Xbit_r29_c28 WL[29] BL[28] BLB[28] VDD GND sram_bitcell
Xbit_r29_c29 WL[29] BL[29] BLB[29] VDD GND sram_bitcell
Xbit_r29_c30 WL[29] BL[30] BLB[30] VDD GND sram_bitcell
Xbit_r29_c31 WL[29] BL[31] BLB[31] VDD GND sram_bitcell
Xbit_r30_c0 WL[30] BL[0] BLB[0] VDD GND sram_bitcell
Xbit_r30_c1 WL[30] BL[1] BLB[1] VDD GND sram_bitcell
Xbit_r30_c2 WL[30] BL[2] BLB[2] VDD GND sram_bitcell
Xbit_r30_c3 WL[30] BL[3] BLB[3] VDD GND sram_bitcell
Xbit_r30_c4 WL[30] BL[4] BLB[4] VDD GND sram_bitcell
Xbit_r30_c5 WL[30] BL[5] BLB[5] VDD GND sram_bitcell
Xbit_r30_c6 WL[30] BL[6] BLB[6] VDD GND sram_bitcell
Xbit_r30_c7 WL[30] BL[7] BLB[7] VDD GND sram_bitcell
Xbit_r30_c8 WL[30] BL[8] BLB[8] VDD GND sram_bitcell
Xbit_r30_c9 WL[30] BL[9] BLB[9] VDD GND sram_bitcell
Xbit_r30_c10 WL[30] BL[10] BLB[10] VDD GND sram_bitcell
Xbit_r30_c11 WL[30] BL[11] BLB[11] VDD GND sram_bitcell
Xbit_r30_c12 WL[30] BL[12] BLB[12] VDD GND sram_bitcell
Xbit_r30_c13 WL[30] BL[13] BLB[13] VDD GND sram_bitcell
Xbit_r30_c14 WL[30] BL[14] BLB[14] VDD GND sram_bitcell
Xbit_r30_c15 WL[30] BL[15] BLB[15] VDD GND sram_bitcell
Xbit_r30_c16 WL[30] BL[16] BLB[16] VDD GND sram_bitcell
Xbit_r30_c17 WL[30] BL[17] BLB[17] VDD GND sram_bitcell
Xbit_r30_c18 WL[30] BL[18] BLB[18] VDD GND sram_bitcell
Xbit_r30_c19 WL[30] BL[19] BLB[19] VDD GND sram_bitcell
Xbit_r30_c20 WL[30] BL[20] BLB[20] VDD GND sram_bitcell
Xbit_r30_c21 WL[30] BL[21] BLB[21] VDD GND sram_bitcell
Xbit_r30_c22 WL[30] BL[22] BLB[22] VDD GND sram_bitcell
Xbit_r30_c23 WL[30] BL[23] BLB[23] VDD GND sram_bitcell
Xbit_r30_c24 WL[30] BL[24] BLB[24] VDD GND sram_bitcell
Xbit_r30_c25 WL[30] BL[25] BLB[25] VDD GND sram_bitcell
Xbit_r30_c26 WL[30] BL[26] BLB[26] VDD GND sram_bitcell
Xbit_r30_c27 WL[30] BL[27] BLB[27] VDD GND sram_bitcell
Xbit_r30_c28 WL[30] BL[28] BLB[28] VDD GND sram_bitcell
Xbit_r30_c29 WL[30] BL[29] BLB[29] VDD GND sram_bitcell
Xbit_r30_c30 WL[30] BL[30] BLB[30] VDD GND sram_bitcell
Xbit_r30_c31 WL[30] BL[31] BLB[31] VDD GND sram_bitcell
Xbit_r31_c0 WL[31] BL[0] BLB[0] VDD GND sram_bitcell
Xbit_r31_c1 WL[31] BL[1] BLB[1] VDD GND sram_bitcell
Xbit_r31_c2 WL[31] BL[2] BLB[2] VDD GND sram_bitcell
Xbit_r31_c3 WL[31] BL[3] BLB[3] VDD GND sram_bitcell
Xbit_r31_c4 WL[31] BL[4] BLB[4] VDD GND sram_bitcell
Xbit_r31_c5 WL[31] BL[5] BLB[5] VDD GND sram_bitcell
Xbit_r31_c6 WL[31] BL[6] BLB[6] VDD GND sram_bitcell
Xbit_r31_c7 WL[31] BL[7] BLB[7] VDD GND sram_bitcell
Xbit_r31_c8 WL[31] BL[8] BLB[8] VDD GND sram_bitcell
Xbit_r31_c9 WL[31] BL[9] BLB[9] VDD GND sram_bitcell
Xbit_r31_c10 WL[31] BL[10] BLB[10] VDD GND sram_bitcell
Xbit_r31_c11 WL[31] BL[11] BLB[11] VDD GND sram_bitcell
Xbit_r31_c12 WL[31] BL[12] BLB[12] VDD GND sram_bitcell
Xbit_r31_c13 WL[31] BL[13] BLB[13] VDD GND sram_bitcell
Xbit_r31_c14 WL[31] BL[14] BLB[14] VDD GND sram_bitcell
Xbit_r31_c15 WL[31] BL[15] BLB[15] VDD GND sram_bitcell
Xbit_r31_c16 WL[31] BL[16] BLB[16] VDD GND sram_bitcell
Xbit_r31_c17 WL[31] BL[17] BLB[17] VDD GND sram_bitcell
Xbit_r31_c18 WL[31] BL[18] BLB[18] VDD GND sram_bitcell
Xbit_r31_c19 WL[31] BL[19] BLB[19] VDD GND sram_bitcell
Xbit_r31_c20 WL[31] BL[20] BLB[20] VDD GND sram_bitcell
Xbit_r31_c21 WL[31] BL[21] BLB[21] VDD GND sram_bitcell
Xbit_r31_c22 WL[31] BL[22] BLB[22] VDD GND sram_bitcell
Xbit_r31_c23 WL[31] BL[23] BLB[23] VDD GND sram_bitcell
Xbit_r31_c24 WL[31] BL[24] BLB[24] VDD GND sram_bitcell
Xbit_r31_c25 WL[31] BL[25] BLB[25] VDD GND sram_bitcell
Xbit_r31_c26 WL[31] BL[26] BLB[26] VDD GND sram_bitcell
Xbit_r31_c27 WL[31] BL[27] BLB[27] VDD GND sram_bitcell
Xbit_r31_c28 WL[31] BL[28] BLB[28] VDD GND sram_bitcell
Xbit_r31_c29 WL[31] BL[29] BLB[29] VDD GND sram_bitcell
Xbit_r31_c30 WL[31] BL[30] BLB[30] VDD GND sram_bitcell
Xbit_r31_c31 WL[31] BL[31] BLB[31] VDD GND sram_bitcell
Xbit_r32_c0 WL[32] BL[0] BLB[0] VDD GND sram_bitcell
Xbit_r32_c1 WL[32] BL[1] BLB[1] VDD GND sram_bitcell
Xbit_r32_c2 WL[32] BL[2] BLB[2] VDD GND sram_bitcell
Xbit_r32_c3 WL[32] BL[3] BLB[3] VDD GND sram_bitcell
Xbit_r32_c4 WL[32] BL[4] BLB[4] VDD GND sram_bitcell
Xbit_r32_c5 WL[32] BL[5] BLB[5] VDD GND sram_bitcell
Xbit_r32_c6 WL[32] BL[6] BLB[6] VDD GND sram_bitcell
Xbit_r32_c7 WL[32] BL[7] BLB[7] VDD GND sram_bitcell
Xbit_r32_c8 WL[32] BL[8] BLB[8] VDD GND sram_bitcell
Xbit_r32_c9 WL[32] BL[9] BLB[9] VDD GND sram_bitcell
Xbit_r32_c10 WL[32] BL[10] BLB[10] VDD GND sram_bitcell
Xbit_r32_c11 WL[32] BL[11] BLB[11] VDD GND sram_bitcell
Xbit_r32_c12 WL[32] BL[12] BLB[12] VDD GND sram_bitcell
Xbit_r32_c13 WL[32] BL[13] BLB[13] VDD GND sram_bitcell
Xbit_r32_c14 WL[32] BL[14] BLB[14] VDD GND sram_bitcell
Xbit_r32_c15 WL[32] BL[15] BLB[15] VDD GND sram_bitcell
Xbit_r32_c16 WL[32] BL[16] BLB[16] VDD GND sram_bitcell
Xbit_r32_c17 WL[32] BL[17] BLB[17] VDD GND sram_bitcell
Xbit_r32_c18 WL[32] BL[18] BLB[18] VDD GND sram_bitcell
Xbit_r32_c19 WL[32] BL[19] BLB[19] VDD GND sram_bitcell
Xbit_r32_c20 WL[32] BL[20] BLB[20] VDD GND sram_bitcell
Xbit_r32_c21 WL[32] BL[21] BLB[21] VDD GND sram_bitcell
Xbit_r32_c22 WL[32] BL[22] BLB[22] VDD GND sram_bitcell
Xbit_r32_c23 WL[32] BL[23] BLB[23] VDD GND sram_bitcell
Xbit_r32_c24 WL[32] BL[24] BLB[24] VDD GND sram_bitcell
Xbit_r32_c25 WL[32] BL[25] BLB[25] VDD GND sram_bitcell
Xbit_r32_c26 WL[32] BL[26] BLB[26] VDD GND sram_bitcell
Xbit_r32_c27 WL[32] BL[27] BLB[27] VDD GND sram_bitcell
Xbit_r32_c28 WL[32] BL[28] BLB[28] VDD GND sram_bitcell
Xbit_r32_c29 WL[32] BL[29] BLB[29] VDD GND sram_bitcell
Xbit_r32_c30 WL[32] BL[30] BLB[30] VDD GND sram_bitcell
Xbit_r32_c31 WL[32] BL[31] BLB[31] VDD GND sram_bitcell
Xbit_r33_c0 WL[33] BL[0] BLB[0] VDD GND sram_bitcell
Xbit_r33_c1 WL[33] BL[1] BLB[1] VDD GND sram_bitcell
Xbit_r33_c2 WL[33] BL[2] BLB[2] VDD GND sram_bitcell
Xbit_r33_c3 WL[33] BL[3] BLB[3] VDD GND sram_bitcell
Xbit_r33_c4 WL[33] BL[4] BLB[4] VDD GND sram_bitcell
Xbit_r33_c5 WL[33] BL[5] BLB[5] VDD GND sram_bitcell
Xbit_r33_c6 WL[33] BL[6] BLB[6] VDD GND sram_bitcell
Xbit_r33_c7 WL[33] BL[7] BLB[7] VDD GND sram_bitcell
Xbit_r33_c8 WL[33] BL[8] BLB[8] VDD GND sram_bitcell
Xbit_r33_c9 WL[33] BL[9] BLB[9] VDD GND sram_bitcell
Xbit_r33_c10 WL[33] BL[10] BLB[10] VDD GND sram_bitcell
Xbit_r33_c11 WL[33] BL[11] BLB[11] VDD GND sram_bitcell
Xbit_r33_c12 WL[33] BL[12] BLB[12] VDD GND sram_bitcell
Xbit_r33_c13 WL[33] BL[13] BLB[13] VDD GND sram_bitcell
Xbit_r33_c14 WL[33] BL[14] BLB[14] VDD GND sram_bitcell
Xbit_r33_c15 WL[33] BL[15] BLB[15] VDD GND sram_bitcell
Xbit_r33_c16 WL[33] BL[16] BLB[16] VDD GND sram_bitcell
Xbit_r33_c17 WL[33] BL[17] BLB[17] VDD GND sram_bitcell
Xbit_r33_c18 WL[33] BL[18] BLB[18] VDD GND sram_bitcell
Xbit_r33_c19 WL[33] BL[19] BLB[19] VDD GND sram_bitcell
Xbit_r33_c20 WL[33] BL[20] BLB[20] VDD GND sram_bitcell
Xbit_r33_c21 WL[33] BL[21] BLB[21] VDD GND sram_bitcell
Xbit_r33_c22 WL[33] BL[22] BLB[22] VDD GND sram_bitcell
Xbit_r33_c23 WL[33] BL[23] BLB[23] VDD GND sram_bitcell
Xbit_r33_c24 WL[33] BL[24] BLB[24] VDD GND sram_bitcell
Xbit_r33_c25 WL[33] BL[25] BLB[25] VDD GND sram_bitcell
Xbit_r33_c26 WL[33] BL[26] BLB[26] VDD GND sram_bitcell
Xbit_r33_c27 WL[33] BL[27] BLB[27] VDD GND sram_bitcell
Xbit_r33_c28 WL[33] BL[28] BLB[28] VDD GND sram_bitcell
Xbit_r33_c29 WL[33] BL[29] BLB[29] VDD GND sram_bitcell
Xbit_r33_c30 WL[33] BL[30] BLB[30] VDD GND sram_bitcell
Xbit_r33_c31 WL[33] BL[31] BLB[31] VDD GND sram_bitcell
Xbit_r34_c0 WL[34] BL[0] BLB[0] VDD GND sram_bitcell
Xbit_r34_c1 WL[34] BL[1] BLB[1] VDD GND sram_bitcell
Xbit_r34_c2 WL[34] BL[2] BLB[2] VDD GND sram_bitcell
Xbit_r34_c3 WL[34] BL[3] BLB[3] VDD GND sram_bitcell
Xbit_r34_c4 WL[34] BL[4] BLB[4] VDD GND sram_bitcell
Xbit_r34_c5 WL[34] BL[5] BLB[5] VDD GND sram_bitcell
Xbit_r34_c6 WL[34] BL[6] BLB[6] VDD GND sram_bitcell
Xbit_r34_c7 WL[34] BL[7] BLB[7] VDD GND sram_bitcell
Xbit_r34_c8 WL[34] BL[8] BLB[8] VDD GND sram_bitcell
Xbit_r34_c9 WL[34] BL[9] BLB[9] VDD GND sram_bitcell
Xbit_r34_c10 WL[34] BL[10] BLB[10] VDD GND sram_bitcell
Xbit_r34_c11 WL[34] BL[11] BLB[11] VDD GND sram_bitcell
Xbit_r34_c12 WL[34] BL[12] BLB[12] VDD GND sram_bitcell
Xbit_r34_c13 WL[34] BL[13] BLB[13] VDD GND sram_bitcell
Xbit_r34_c14 WL[34] BL[14] BLB[14] VDD GND sram_bitcell
Xbit_r34_c15 WL[34] BL[15] BLB[15] VDD GND sram_bitcell
Xbit_r34_c16 WL[34] BL[16] BLB[16] VDD GND sram_bitcell
Xbit_r34_c17 WL[34] BL[17] BLB[17] VDD GND sram_bitcell
Xbit_r34_c18 WL[34] BL[18] BLB[18] VDD GND sram_bitcell
Xbit_r34_c19 WL[34] BL[19] BLB[19] VDD GND sram_bitcell
Xbit_r34_c20 WL[34] BL[20] BLB[20] VDD GND sram_bitcell
Xbit_r34_c21 WL[34] BL[21] BLB[21] VDD GND sram_bitcell
Xbit_r34_c22 WL[34] BL[22] BLB[22] VDD GND sram_bitcell
Xbit_r34_c23 WL[34] BL[23] BLB[23] VDD GND sram_bitcell
Xbit_r34_c24 WL[34] BL[24] BLB[24] VDD GND sram_bitcell
Xbit_r34_c25 WL[34] BL[25] BLB[25] VDD GND sram_bitcell
Xbit_r34_c26 WL[34] BL[26] BLB[26] VDD GND sram_bitcell
Xbit_r34_c27 WL[34] BL[27] BLB[27] VDD GND sram_bitcell
Xbit_r34_c28 WL[34] BL[28] BLB[28] VDD GND sram_bitcell
Xbit_r34_c29 WL[34] BL[29] BLB[29] VDD GND sram_bitcell
Xbit_r34_c30 WL[34] BL[30] BLB[30] VDD GND sram_bitcell
Xbit_r34_c31 WL[34] BL[31] BLB[31] VDD GND sram_bitcell
Xbit_r35_c0 WL[35] BL[0] BLB[0] VDD GND sram_bitcell
Xbit_r35_c1 WL[35] BL[1] BLB[1] VDD GND sram_bitcell
Xbit_r35_c2 WL[35] BL[2] BLB[2] VDD GND sram_bitcell
Xbit_r35_c3 WL[35] BL[3] BLB[3] VDD GND sram_bitcell
Xbit_r35_c4 WL[35] BL[4] BLB[4] VDD GND sram_bitcell
Xbit_r35_c5 WL[35] BL[5] BLB[5] VDD GND sram_bitcell
Xbit_r35_c6 WL[35] BL[6] BLB[6] VDD GND sram_bitcell
Xbit_r35_c7 WL[35] BL[7] BLB[7] VDD GND sram_bitcell
Xbit_r35_c8 WL[35] BL[8] BLB[8] VDD GND sram_bitcell
Xbit_r35_c9 WL[35] BL[9] BLB[9] VDD GND sram_bitcell
Xbit_r35_c10 WL[35] BL[10] BLB[10] VDD GND sram_bitcell
Xbit_r35_c11 WL[35] BL[11] BLB[11] VDD GND sram_bitcell
Xbit_r35_c12 WL[35] BL[12] BLB[12] VDD GND sram_bitcell
Xbit_r35_c13 WL[35] BL[13] BLB[13] VDD GND sram_bitcell
Xbit_r35_c14 WL[35] BL[14] BLB[14] VDD GND sram_bitcell
Xbit_r35_c15 WL[35] BL[15] BLB[15] VDD GND sram_bitcell
Xbit_r35_c16 WL[35] BL[16] BLB[16] VDD GND sram_bitcell
Xbit_r35_c17 WL[35] BL[17] BLB[17] VDD GND sram_bitcell
Xbit_r35_c18 WL[35] BL[18] BLB[18] VDD GND sram_bitcell
Xbit_r35_c19 WL[35] BL[19] BLB[19] VDD GND sram_bitcell
Xbit_r35_c20 WL[35] BL[20] BLB[20] VDD GND sram_bitcell
Xbit_r35_c21 WL[35] BL[21] BLB[21] VDD GND sram_bitcell
Xbit_r35_c22 WL[35] BL[22] BLB[22] VDD GND sram_bitcell
Xbit_r35_c23 WL[35] BL[23] BLB[23] VDD GND sram_bitcell
Xbit_r35_c24 WL[35] BL[24] BLB[24] VDD GND sram_bitcell
Xbit_r35_c25 WL[35] BL[25] BLB[25] VDD GND sram_bitcell
Xbit_r35_c26 WL[35] BL[26] BLB[26] VDD GND sram_bitcell
Xbit_r35_c27 WL[35] BL[27] BLB[27] VDD GND sram_bitcell
Xbit_r35_c28 WL[35] BL[28] BLB[28] VDD GND sram_bitcell
Xbit_r35_c29 WL[35] BL[29] BLB[29] VDD GND sram_bitcell
Xbit_r35_c30 WL[35] BL[30] BLB[30] VDD GND sram_bitcell
Xbit_r35_c31 WL[35] BL[31] BLB[31] VDD GND sram_bitcell
Xbit_r36_c0 WL[36] BL[0] BLB[0] VDD GND sram_bitcell
Xbit_r36_c1 WL[36] BL[1] BLB[1] VDD GND sram_bitcell
Xbit_r36_c2 WL[36] BL[2] BLB[2] VDD GND sram_bitcell
Xbit_r36_c3 WL[36] BL[3] BLB[3] VDD GND sram_bitcell
Xbit_r36_c4 WL[36] BL[4] BLB[4] VDD GND sram_bitcell
Xbit_r36_c5 WL[36] BL[5] BLB[5] VDD GND sram_bitcell
Xbit_r36_c6 WL[36] BL[6] BLB[6] VDD GND sram_bitcell
Xbit_r36_c7 WL[36] BL[7] BLB[7] VDD GND sram_bitcell
Xbit_r36_c8 WL[36] BL[8] BLB[8] VDD GND sram_bitcell
Xbit_r36_c9 WL[36] BL[9] BLB[9] VDD GND sram_bitcell
Xbit_r36_c10 WL[36] BL[10] BLB[10] VDD GND sram_bitcell
Xbit_r36_c11 WL[36] BL[11] BLB[11] VDD GND sram_bitcell
Xbit_r36_c12 WL[36] BL[12] BLB[12] VDD GND sram_bitcell
Xbit_r36_c13 WL[36] BL[13] BLB[13] VDD GND sram_bitcell
Xbit_r36_c14 WL[36] BL[14] BLB[14] VDD GND sram_bitcell
Xbit_r36_c15 WL[36] BL[15] BLB[15] VDD GND sram_bitcell
Xbit_r36_c16 WL[36] BL[16] BLB[16] VDD GND sram_bitcell
Xbit_r36_c17 WL[36] BL[17] BLB[17] VDD GND sram_bitcell
Xbit_r36_c18 WL[36] BL[18] BLB[18] VDD GND sram_bitcell
Xbit_r36_c19 WL[36] BL[19] BLB[19] VDD GND sram_bitcell
Xbit_r36_c20 WL[36] BL[20] BLB[20] VDD GND sram_bitcell
Xbit_r36_c21 WL[36] BL[21] BLB[21] VDD GND sram_bitcell
Xbit_r36_c22 WL[36] BL[22] BLB[22] VDD GND sram_bitcell
Xbit_r36_c23 WL[36] BL[23] BLB[23] VDD GND sram_bitcell
Xbit_r36_c24 WL[36] BL[24] BLB[24] VDD GND sram_bitcell
Xbit_r36_c25 WL[36] BL[25] BLB[25] VDD GND sram_bitcell
Xbit_r36_c26 WL[36] BL[26] BLB[26] VDD GND sram_bitcell
Xbit_r36_c27 WL[36] BL[27] BLB[27] VDD GND sram_bitcell
Xbit_r36_c28 WL[36] BL[28] BLB[28] VDD GND sram_bitcell
Xbit_r36_c29 WL[36] BL[29] BLB[29] VDD GND sram_bitcell
Xbit_r36_c30 WL[36] BL[30] BLB[30] VDD GND sram_bitcell
Xbit_r36_c31 WL[36] BL[31] BLB[31] VDD GND sram_bitcell
Xbit_r37_c0 WL[37] BL[0] BLB[0] VDD GND sram_bitcell
Xbit_r37_c1 WL[37] BL[1] BLB[1] VDD GND sram_bitcell
Xbit_r37_c2 WL[37] BL[2] BLB[2] VDD GND sram_bitcell
Xbit_r37_c3 WL[37] BL[3] BLB[3] VDD GND sram_bitcell
Xbit_r37_c4 WL[37] BL[4] BLB[4] VDD GND sram_bitcell
Xbit_r37_c5 WL[37] BL[5] BLB[5] VDD GND sram_bitcell
Xbit_r37_c6 WL[37] BL[6] BLB[6] VDD GND sram_bitcell
Xbit_r37_c7 WL[37] BL[7] BLB[7] VDD GND sram_bitcell
Xbit_r37_c8 WL[37] BL[8] BLB[8] VDD GND sram_bitcell
Xbit_r37_c9 WL[37] BL[9] BLB[9] VDD GND sram_bitcell
Xbit_r37_c10 WL[37] BL[10] BLB[10] VDD GND sram_bitcell
Xbit_r37_c11 WL[37] BL[11] BLB[11] VDD GND sram_bitcell
Xbit_r37_c12 WL[37] BL[12] BLB[12] VDD GND sram_bitcell
Xbit_r37_c13 WL[37] BL[13] BLB[13] VDD GND sram_bitcell
Xbit_r37_c14 WL[37] BL[14] BLB[14] VDD GND sram_bitcell
Xbit_r37_c15 WL[37] BL[15] BLB[15] VDD GND sram_bitcell
Xbit_r37_c16 WL[37] BL[16] BLB[16] VDD GND sram_bitcell
Xbit_r37_c17 WL[37] BL[17] BLB[17] VDD GND sram_bitcell
Xbit_r37_c18 WL[37] BL[18] BLB[18] VDD GND sram_bitcell
Xbit_r37_c19 WL[37] BL[19] BLB[19] VDD GND sram_bitcell
Xbit_r37_c20 WL[37] BL[20] BLB[20] VDD GND sram_bitcell
Xbit_r37_c21 WL[37] BL[21] BLB[21] VDD GND sram_bitcell
Xbit_r37_c22 WL[37] BL[22] BLB[22] VDD GND sram_bitcell
Xbit_r37_c23 WL[37] BL[23] BLB[23] VDD GND sram_bitcell
Xbit_r37_c24 WL[37] BL[24] BLB[24] VDD GND sram_bitcell
Xbit_r37_c25 WL[37] BL[25] BLB[25] VDD GND sram_bitcell
Xbit_r37_c26 WL[37] BL[26] BLB[26] VDD GND sram_bitcell
Xbit_r37_c27 WL[37] BL[27] BLB[27] VDD GND sram_bitcell
Xbit_r37_c28 WL[37] BL[28] BLB[28] VDD GND sram_bitcell
Xbit_r37_c29 WL[37] BL[29] BLB[29] VDD GND sram_bitcell
Xbit_r37_c30 WL[37] BL[30] BLB[30] VDD GND sram_bitcell
Xbit_r37_c31 WL[37] BL[31] BLB[31] VDD GND sram_bitcell
Xbit_r38_c0 WL[38] BL[0] BLB[0] VDD GND sram_bitcell
Xbit_r38_c1 WL[38] BL[1] BLB[1] VDD GND sram_bitcell
Xbit_r38_c2 WL[38] BL[2] BLB[2] VDD GND sram_bitcell
Xbit_r38_c3 WL[38] BL[3] BLB[3] VDD GND sram_bitcell
Xbit_r38_c4 WL[38] BL[4] BLB[4] VDD GND sram_bitcell
Xbit_r38_c5 WL[38] BL[5] BLB[5] VDD GND sram_bitcell
Xbit_r38_c6 WL[38] BL[6] BLB[6] VDD GND sram_bitcell
Xbit_r38_c7 WL[38] BL[7] BLB[7] VDD GND sram_bitcell
Xbit_r38_c8 WL[38] BL[8] BLB[8] VDD GND sram_bitcell
Xbit_r38_c9 WL[38] BL[9] BLB[9] VDD GND sram_bitcell
Xbit_r38_c10 WL[38] BL[10] BLB[10] VDD GND sram_bitcell
Xbit_r38_c11 WL[38] BL[11] BLB[11] VDD GND sram_bitcell
Xbit_r38_c12 WL[38] BL[12] BLB[12] VDD GND sram_bitcell
Xbit_r38_c13 WL[38] BL[13] BLB[13] VDD GND sram_bitcell
Xbit_r38_c14 WL[38] BL[14] BLB[14] VDD GND sram_bitcell
Xbit_r38_c15 WL[38] BL[15] BLB[15] VDD GND sram_bitcell
Xbit_r38_c16 WL[38] BL[16] BLB[16] VDD GND sram_bitcell
Xbit_r38_c17 WL[38] BL[17] BLB[17] VDD GND sram_bitcell
Xbit_r38_c18 WL[38] BL[18] BLB[18] VDD GND sram_bitcell
Xbit_r38_c19 WL[38] BL[19] BLB[19] VDD GND sram_bitcell
Xbit_r38_c20 WL[38] BL[20] BLB[20] VDD GND sram_bitcell
Xbit_r38_c21 WL[38] BL[21] BLB[21] VDD GND sram_bitcell
Xbit_r38_c22 WL[38] BL[22] BLB[22] VDD GND sram_bitcell
Xbit_r38_c23 WL[38] BL[23] BLB[23] VDD GND sram_bitcell
Xbit_r38_c24 WL[38] BL[24] BLB[24] VDD GND sram_bitcell
Xbit_r38_c25 WL[38] BL[25] BLB[25] VDD GND sram_bitcell
Xbit_r38_c26 WL[38] BL[26] BLB[26] VDD GND sram_bitcell
Xbit_r38_c27 WL[38] BL[27] BLB[27] VDD GND sram_bitcell
Xbit_r38_c28 WL[38] BL[28] BLB[28] VDD GND sram_bitcell
Xbit_r38_c29 WL[38] BL[29] BLB[29] VDD GND sram_bitcell
Xbit_r38_c30 WL[38] BL[30] BLB[30] VDD GND sram_bitcell
Xbit_r38_c31 WL[38] BL[31] BLB[31] VDD GND sram_bitcell
Xbit_r39_c0 WL[39] BL[0] BLB[0] VDD GND sram_bitcell
Xbit_r39_c1 WL[39] BL[1] BLB[1] VDD GND sram_bitcell
Xbit_r39_c2 WL[39] BL[2] BLB[2] VDD GND sram_bitcell
Xbit_r39_c3 WL[39] BL[3] BLB[3] VDD GND sram_bitcell
Xbit_r39_c4 WL[39] BL[4] BLB[4] VDD GND sram_bitcell
Xbit_r39_c5 WL[39] BL[5] BLB[5] VDD GND sram_bitcell
Xbit_r39_c6 WL[39] BL[6] BLB[6] VDD GND sram_bitcell
Xbit_r39_c7 WL[39] BL[7] BLB[7] VDD GND sram_bitcell
Xbit_r39_c8 WL[39] BL[8] BLB[8] VDD GND sram_bitcell
Xbit_r39_c9 WL[39] BL[9] BLB[9] VDD GND sram_bitcell
Xbit_r39_c10 WL[39] BL[10] BLB[10] VDD GND sram_bitcell
Xbit_r39_c11 WL[39] BL[11] BLB[11] VDD GND sram_bitcell
Xbit_r39_c12 WL[39] BL[12] BLB[12] VDD GND sram_bitcell
Xbit_r39_c13 WL[39] BL[13] BLB[13] VDD GND sram_bitcell
Xbit_r39_c14 WL[39] BL[14] BLB[14] VDD GND sram_bitcell
Xbit_r39_c15 WL[39] BL[15] BLB[15] VDD GND sram_bitcell
Xbit_r39_c16 WL[39] BL[16] BLB[16] VDD GND sram_bitcell
Xbit_r39_c17 WL[39] BL[17] BLB[17] VDD GND sram_bitcell
Xbit_r39_c18 WL[39] BL[18] BLB[18] VDD GND sram_bitcell
Xbit_r39_c19 WL[39] BL[19] BLB[19] VDD GND sram_bitcell
Xbit_r39_c20 WL[39] BL[20] BLB[20] VDD GND sram_bitcell
Xbit_r39_c21 WL[39] BL[21] BLB[21] VDD GND sram_bitcell
Xbit_r39_c22 WL[39] BL[22] BLB[22] VDD GND sram_bitcell
Xbit_r39_c23 WL[39] BL[23] BLB[23] VDD GND sram_bitcell
Xbit_r39_c24 WL[39] BL[24] BLB[24] VDD GND sram_bitcell
Xbit_r39_c25 WL[39] BL[25] BLB[25] VDD GND sram_bitcell
Xbit_r39_c26 WL[39] BL[26] BLB[26] VDD GND sram_bitcell
Xbit_r39_c27 WL[39] BL[27] BLB[27] VDD GND sram_bitcell
Xbit_r39_c28 WL[39] BL[28] BLB[28] VDD GND sram_bitcell
Xbit_r39_c29 WL[39] BL[29] BLB[29] VDD GND sram_bitcell
Xbit_r39_c30 WL[39] BL[30] BLB[30] VDD GND sram_bitcell
Xbit_r39_c31 WL[39] BL[31] BLB[31] VDD GND sram_bitcell
Xbit_r40_c0 WL[40] BL[0] BLB[0] VDD GND sram_bitcell
Xbit_r40_c1 WL[40] BL[1] BLB[1] VDD GND sram_bitcell
Xbit_r40_c2 WL[40] BL[2] BLB[2] VDD GND sram_bitcell
Xbit_r40_c3 WL[40] BL[3] BLB[3] VDD GND sram_bitcell
Xbit_r40_c4 WL[40] BL[4] BLB[4] VDD GND sram_bitcell
Xbit_r40_c5 WL[40] BL[5] BLB[5] VDD GND sram_bitcell
Xbit_r40_c6 WL[40] BL[6] BLB[6] VDD GND sram_bitcell
Xbit_r40_c7 WL[40] BL[7] BLB[7] VDD GND sram_bitcell
Xbit_r40_c8 WL[40] BL[8] BLB[8] VDD GND sram_bitcell
Xbit_r40_c9 WL[40] BL[9] BLB[9] VDD GND sram_bitcell
Xbit_r40_c10 WL[40] BL[10] BLB[10] VDD GND sram_bitcell
Xbit_r40_c11 WL[40] BL[11] BLB[11] VDD GND sram_bitcell
Xbit_r40_c12 WL[40] BL[12] BLB[12] VDD GND sram_bitcell
Xbit_r40_c13 WL[40] BL[13] BLB[13] VDD GND sram_bitcell
Xbit_r40_c14 WL[40] BL[14] BLB[14] VDD GND sram_bitcell
Xbit_r40_c15 WL[40] BL[15] BLB[15] VDD GND sram_bitcell
Xbit_r40_c16 WL[40] BL[16] BLB[16] VDD GND sram_bitcell
Xbit_r40_c17 WL[40] BL[17] BLB[17] VDD GND sram_bitcell
Xbit_r40_c18 WL[40] BL[18] BLB[18] VDD GND sram_bitcell
Xbit_r40_c19 WL[40] BL[19] BLB[19] VDD GND sram_bitcell
Xbit_r40_c20 WL[40] BL[20] BLB[20] VDD GND sram_bitcell
Xbit_r40_c21 WL[40] BL[21] BLB[21] VDD GND sram_bitcell
Xbit_r40_c22 WL[40] BL[22] BLB[22] VDD GND sram_bitcell
Xbit_r40_c23 WL[40] BL[23] BLB[23] VDD GND sram_bitcell
Xbit_r40_c24 WL[40] BL[24] BLB[24] VDD GND sram_bitcell
Xbit_r40_c25 WL[40] BL[25] BLB[25] VDD GND sram_bitcell
Xbit_r40_c26 WL[40] BL[26] BLB[26] VDD GND sram_bitcell
Xbit_r40_c27 WL[40] BL[27] BLB[27] VDD GND sram_bitcell
Xbit_r40_c28 WL[40] BL[28] BLB[28] VDD GND sram_bitcell
Xbit_r40_c29 WL[40] BL[29] BLB[29] VDD GND sram_bitcell
Xbit_r40_c30 WL[40] BL[30] BLB[30] VDD GND sram_bitcell
Xbit_r40_c31 WL[40] BL[31] BLB[31] VDD GND sram_bitcell
Xbit_r41_c0 WL[41] BL[0] BLB[0] VDD GND sram_bitcell
Xbit_r41_c1 WL[41] BL[1] BLB[1] VDD GND sram_bitcell
Xbit_r41_c2 WL[41] BL[2] BLB[2] VDD GND sram_bitcell
Xbit_r41_c3 WL[41] BL[3] BLB[3] VDD GND sram_bitcell
Xbit_r41_c4 WL[41] BL[4] BLB[4] VDD GND sram_bitcell
Xbit_r41_c5 WL[41] BL[5] BLB[5] VDD GND sram_bitcell
Xbit_r41_c6 WL[41] BL[6] BLB[6] VDD GND sram_bitcell
Xbit_r41_c7 WL[41] BL[7] BLB[7] VDD GND sram_bitcell
Xbit_r41_c8 WL[41] BL[8] BLB[8] VDD GND sram_bitcell
Xbit_r41_c9 WL[41] BL[9] BLB[9] VDD GND sram_bitcell
Xbit_r41_c10 WL[41] BL[10] BLB[10] VDD GND sram_bitcell
Xbit_r41_c11 WL[41] BL[11] BLB[11] VDD GND sram_bitcell
Xbit_r41_c12 WL[41] BL[12] BLB[12] VDD GND sram_bitcell
Xbit_r41_c13 WL[41] BL[13] BLB[13] VDD GND sram_bitcell
Xbit_r41_c14 WL[41] BL[14] BLB[14] VDD GND sram_bitcell
Xbit_r41_c15 WL[41] BL[15] BLB[15] VDD GND sram_bitcell
Xbit_r41_c16 WL[41] BL[16] BLB[16] VDD GND sram_bitcell
Xbit_r41_c17 WL[41] BL[17] BLB[17] VDD GND sram_bitcell
Xbit_r41_c18 WL[41] BL[18] BLB[18] VDD GND sram_bitcell
Xbit_r41_c19 WL[41] BL[19] BLB[19] VDD GND sram_bitcell
Xbit_r41_c20 WL[41] BL[20] BLB[20] VDD GND sram_bitcell
Xbit_r41_c21 WL[41] BL[21] BLB[21] VDD GND sram_bitcell
Xbit_r41_c22 WL[41] BL[22] BLB[22] VDD GND sram_bitcell
Xbit_r41_c23 WL[41] BL[23] BLB[23] VDD GND sram_bitcell
Xbit_r41_c24 WL[41] BL[24] BLB[24] VDD GND sram_bitcell
Xbit_r41_c25 WL[41] BL[25] BLB[25] VDD GND sram_bitcell
Xbit_r41_c26 WL[41] BL[26] BLB[26] VDD GND sram_bitcell
Xbit_r41_c27 WL[41] BL[27] BLB[27] VDD GND sram_bitcell
Xbit_r41_c28 WL[41] BL[28] BLB[28] VDD GND sram_bitcell
Xbit_r41_c29 WL[41] BL[29] BLB[29] VDD GND sram_bitcell
Xbit_r41_c30 WL[41] BL[30] BLB[30] VDD GND sram_bitcell
Xbit_r41_c31 WL[41] BL[31] BLB[31] VDD GND sram_bitcell
Xbit_r42_c0 WL[42] BL[0] BLB[0] VDD GND sram_bitcell
Xbit_r42_c1 WL[42] BL[1] BLB[1] VDD GND sram_bitcell
Xbit_r42_c2 WL[42] BL[2] BLB[2] VDD GND sram_bitcell
Xbit_r42_c3 WL[42] BL[3] BLB[3] VDD GND sram_bitcell
Xbit_r42_c4 WL[42] BL[4] BLB[4] VDD GND sram_bitcell
Xbit_r42_c5 WL[42] BL[5] BLB[5] VDD GND sram_bitcell
Xbit_r42_c6 WL[42] BL[6] BLB[6] VDD GND sram_bitcell
Xbit_r42_c7 WL[42] BL[7] BLB[7] VDD GND sram_bitcell
Xbit_r42_c8 WL[42] BL[8] BLB[8] VDD GND sram_bitcell
Xbit_r42_c9 WL[42] BL[9] BLB[9] VDD GND sram_bitcell
Xbit_r42_c10 WL[42] BL[10] BLB[10] VDD GND sram_bitcell
Xbit_r42_c11 WL[42] BL[11] BLB[11] VDD GND sram_bitcell
Xbit_r42_c12 WL[42] BL[12] BLB[12] VDD GND sram_bitcell
Xbit_r42_c13 WL[42] BL[13] BLB[13] VDD GND sram_bitcell
Xbit_r42_c14 WL[42] BL[14] BLB[14] VDD GND sram_bitcell
Xbit_r42_c15 WL[42] BL[15] BLB[15] VDD GND sram_bitcell
Xbit_r42_c16 WL[42] BL[16] BLB[16] VDD GND sram_bitcell
Xbit_r42_c17 WL[42] BL[17] BLB[17] VDD GND sram_bitcell
Xbit_r42_c18 WL[42] BL[18] BLB[18] VDD GND sram_bitcell
Xbit_r42_c19 WL[42] BL[19] BLB[19] VDD GND sram_bitcell
Xbit_r42_c20 WL[42] BL[20] BLB[20] VDD GND sram_bitcell
Xbit_r42_c21 WL[42] BL[21] BLB[21] VDD GND sram_bitcell
Xbit_r42_c22 WL[42] BL[22] BLB[22] VDD GND sram_bitcell
Xbit_r42_c23 WL[42] BL[23] BLB[23] VDD GND sram_bitcell
Xbit_r42_c24 WL[42] BL[24] BLB[24] VDD GND sram_bitcell
Xbit_r42_c25 WL[42] BL[25] BLB[25] VDD GND sram_bitcell
Xbit_r42_c26 WL[42] BL[26] BLB[26] VDD GND sram_bitcell
Xbit_r42_c27 WL[42] BL[27] BLB[27] VDD GND sram_bitcell
Xbit_r42_c28 WL[42] BL[28] BLB[28] VDD GND sram_bitcell
Xbit_r42_c29 WL[42] BL[29] BLB[29] VDD GND sram_bitcell
Xbit_r42_c30 WL[42] BL[30] BLB[30] VDD GND sram_bitcell
Xbit_r42_c31 WL[42] BL[31] BLB[31] VDD GND sram_bitcell
Xbit_r43_c0 WL[43] BL[0] BLB[0] VDD GND sram_bitcell
Xbit_r43_c1 WL[43] BL[1] BLB[1] VDD GND sram_bitcell
Xbit_r43_c2 WL[43] BL[2] BLB[2] VDD GND sram_bitcell
Xbit_r43_c3 WL[43] BL[3] BLB[3] VDD GND sram_bitcell
Xbit_r43_c4 WL[43] BL[4] BLB[4] VDD GND sram_bitcell
Xbit_r43_c5 WL[43] BL[5] BLB[5] VDD GND sram_bitcell
Xbit_r43_c6 WL[43] BL[6] BLB[6] VDD GND sram_bitcell
Xbit_r43_c7 WL[43] BL[7] BLB[7] VDD GND sram_bitcell
Xbit_r43_c8 WL[43] BL[8] BLB[8] VDD GND sram_bitcell
Xbit_r43_c9 WL[43] BL[9] BLB[9] VDD GND sram_bitcell
Xbit_r43_c10 WL[43] BL[10] BLB[10] VDD GND sram_bitcell
Xbit_r43_c11 WL[43] BL[11] BLB[11] VDD GND sram_bitcell
Xbit_r43_c12 WL[43] BL[12] BLB[12] VDD GND sram_bitcell
Xbit_r43_c13 WL[43] BL[13] BLB[13] VDD GND sram_bitcell
Xbit_r43_c14 WL[43] BL[14] BLB[14] VDD GND sram_bitcell
Xbit_r43_c15 WL[43] BL[15] BLB[15] VDD GND sram_bitcell
Xbit_r43_c16 WL[43] BL[16] BLB[16] VDD GND sram_bitcell
Xbit_r43_c17 WL[43] BL[17] BLB[17] VDD GND sram_bitcell
Xbit_r43_c18 WL[43] BL[18] BLB[18] VDD GND sram_bitcell
Xbit_r43_c19 WL[43] BL[19] BLB[19] VDD GND sram_bitcell
Xbit_r43_c20 WL[43] BL[20] BLB[20] VDD GND sram_bitcell
Xbit_r43_c21 WL[43] BL[21] BLB[21] VDD GND sram_bitcell
Xbit_r43_c22 WL[43] BL[22] BLB[22] VDD GND sram_bitcell
Xbit_r43_c23 WL[43] BL[23] BLB[23] VDD GND sram_bitcell
Xbit_r43_c24 WL[43] BL[24] BLB[24] VDD GND sram_bitcell
Xbit_r43_c25 WL[43] BL[25] BLB[25] VDD GND sram_bitcell
Xbit_r43_c26 WL[43] BL[26] BLB[26] VDD GND sram_bitcell
Xbit_r43_c27 WL[43] BL[27] BLB[27] VDD GND sram_bitcell
Xbit_r43_c28 WL[43] BL[28] BLB[28] VDD GND sram_bitcell
Xbit_r43_c29 WL[43] BL[29] BLB[29] VDD GND sram_bitcell
Xbit_r43_c30 WL[43] BL[30] BLB[30] VDD GND sram_bitcell
Xbit_r43_c31 WL[43] BL[31] BLB[31] VDD GND sram_bitcell
Xbit_r44_c0 WL[44] BL[0] BLB[0] VDD GND sram_bitcell
Xbit_r44_c1 WL[44] BL[1] BLB[1] VDD GND sram_bitcell
Xbit_r44_c2 WL[44] BL[2] BLB[2] VDD GND sram_bitcell
Xbit_r44_c3 WL[44] BL[3] BLB[3] VDD GND sram_bitcell
Xbit_r44_c4 WL[44] BL[4] BLB[4] VDD GND sram_bitcell
Xbit_r44_c5 WL[44] BL[5] BLB[5] VDD GND sram_bitcell
Xbit_r44_c6 WL[44] BL[6] BLB[6] VDD GND sram_bitcell
Xbit_r44_c7 WL[44] BL[7] BLB[7] VDD GND sram_bitcell
Xbit_r44_c8 WL[44] BL[8] BLB[8] VDD GND sram_bitcell
Xbit_r44_c9 WL[44] BL[9] BLB[9] VDD GND sram_bitcell
Xbit_r44_c10 WL[44] BL[10] BLB[10] VDD GND sram_bitcell
Xbit_r44_c11 WL[44] BL[11] BLB[11] VDD GND sram_bitcell
Xbit_r44_c12 WL[44] BL[12] BLB[12] VDD GND sram_bitcell
Xbit_r44_c13 WL[44] BL[13] BLB[13] VDD GND sram_bitcell
Xbit_r44_c14 WL[44] BL[14] BLB[14] VDD GND sram_bitcell
Xbit_r44_c15 WL[44] BL[15] BLB[15] VDD GND sram_bitcell
Xbit_r44_c16 WL[44] BL[16] BLB[16] VDD GND sram_bitcell
Xbit_r44_c17 WL[44] BL[17] BLB[17] VDD GND sram_bitcell
Xbit_r44_c18 WL[44] BL[18] BLB[18] VDD GND sram_bitcell
Xbit_r44_c19 WL[44] BL[19] BLB[19] VDD GND sram_bitcell
Xbit_r44_c20 WL[44] BL[20] BLB[20] VDD GND sram_bitcell
Xbit_r44_c21 WL[44] BL[21] BLB[21] VDD GND sram_bitcell
Xbit_r44_c22 WL[44] BL[22] BLB[22] VDD GND sram_bitcell
Xbit_r44_c23 WL[44] BL[23] BLB[23] VDD GND sram_bitcell
Xbit_r44_c24 WL[44] BL[24] BLB[24] VDD GND sram_bitcell
Xbit_r44_c25 WL[44] BL[25] BLB[25] VDD GND sram_bitcell
Xbit_r44_c26 WL[44] BL[26] BLB[26] VDD GND sram_bitcell
Xbit_r44_c27 WL[44] BL[27] BLB[27] VDD GND sram_bitcell
Xbit_r44_c28 WL[44] BL[28] BLB[28] VDD GND sram_bitcell
Xbit_r44_c29 WL[44] BL[29] BLB[29] VDD GND sram_bitcell
Xbit_r44_c30 WL[44] BL[30] BLB[30] VDD GND sram_bitcell
Xbit_r44_c31 WL[44] BL[31] BLB[31] VDD GND sram_bitcell
Xbit_r45_c0 WL[45] BL[0] BLB[0] VDD GND sram_bitcell
Xbit_r45_c1 WL[45] BL[1] BLB[1] VDD GND sram_bitcell
Xbit_r45_c2 WL[45] BL[2] BLB[2] VDD GND sram_bitcell
Xbit_r45_c3 WL[45] BL[3] BLB[3] VDD GND sram_bitcell
Xbit_r45_c4 WL[45] BL[4] BLB[4] VDD GND sram_bitcell
Xbit_r45_c5 WL[45] BL[5] BLB[5] VDD GND sram_bitcell
Xbit_r45_c6 WL[45] BL[6] BLB[6] VDD GND sram_bitcell
Xbit_r45_c7 WL[45] BL[7] BLB[7] VDD GND sram_bitcell
Xbit_r45_c8 WL[45] BL[8] BLB[8] VDD GND sram_bitcell
Xbit_r45_c9 WL[45] BL[9] BLB[9] VDD GND sram_bitcell
Xbit_r45_c10 WL[45] BL[10] BLB[10] VDD GND sram_bitcell
Xbit_r45_c11 WL[45] BL[11] BLB[11] VDD GND sram_bitcell
Xbit_r45_c12 WL[45] BL[12] BLB[12] VDD GND sram_bitcell
Xbit_r45_c13 WL[45] BL[13] BLB[13] VDD GND sram_bitcell
Xbit_r45_c14 WL[45] BL[14] BLB[14] VDD GND sram_bitcell
Xbit_r45_c15 WL[45] BL[15] BLB[15] VDD GND sram_bitcell
Xbit_r45_c16 WL[45] BL[16] BLB[16] VDD GND sram_bitcell
Xbit_r45_c17 WL[45] BL[17] BLB[17] VDD GND sram_bitcell
Xbit_r45_c18 WL[45] BL[18] BLB[18] VDD GND sram_bitcell
Xbit_r45_c19 WL[45] BL[19] BLB[19] VDD GND sram_bitcell
Xbit_r45_c20 WL[45] BL[20] BLB[20] VDD GND sram_bitcell
Xbit_r45_c21 WL[45] BL[21] BLB[21] VDD GND sram_bitcell
Xbit_r45_c22 WL[45] BL[22] BLB[22] VDD GND sram_bitcell
Xbit_r45_c23 WL[45] BL[23] BLB[23] VDD GND sram_bitcell
Xbit_r45_c24 WL[45] BL[24] BLB[24] VDD GND sram_bitcell
Xbit_r45_c25 WL[45] BL[25] BLB[25] VDD GND sram_bitcell
Xbit_r45_c26 WL[45] BL[26] BLB[26] VDD GND sram_bitcell
Xbit_r45_c27 WL[45] BL[27] BLB[27] VDD GND sram_bitcell
Xbit_r45_c28 WL[45] BL[28] BLB[28] VDD GND sram_bitcell
Xbit_r45_c29 WL[45] BL[29] BLB[29] VDD GND sram_bitcell
Xbit_r45_c30 WL[45] BL[30] BLB[30] VDD GND sram_bitcell
Xbit_r45_c31 WL[45] BL[31] BLB[31] VDD GND sram_bitcell
Xbit_r46_c0 WL[46] BL[0] BLB[0] VDD GND sram_bitcell
Xbit_r46_c1 WL[46] BL[1] BLB[1] VDD GND sram_bitcell
Xbit_r46_c2 WL[46] BL[2] BLB[2] VDD GND sram_bitcell
Xbit_r46_c3 WL[46] BL[3] BLB[3] VDD GND sram_bitcell
Xbit_r46_c4 WL[46] BL[4] BLB[4] VDD GND sram_bitcell
Xbit_r46_c5 WL[46] BL[5] BLB[5] VDD GND sram_bitcell
Xbit_r46_c6 WL[46] BL[6] BLB[6] VDD GND sram_bitcell
Xbit_r46_c7 WL[46] BL[7] BLB[7] VDD GND sram_bitcell
Xbit_r46_c8 WL[46] BL[8] BLB[8] VDD GND sram_bitcell
Xbit_r46_c9 WL[46] BL[9] BLB[9] VDD GND sram_bitcell
Xbit_r46_c10 WL[46] BL[10] BLB[10] VDD GND sram_bitcell
Xbit_r46_c11 WL[46] BL[11] BLB[11] VDD GND sram_bitcell
Xbit_r46_c12 WL[46] BL[12] BLB[12] VDD GND sram_bitcell
Xbit_r46_c13 WL[46] BL[13] BLB[13] VDD GND sram_bitcell
Xbit_r46_c14 WL[46] BL[14] BLB[14] VDD GND sram_bitcell
Xbit_r46_c15 WL[46] BL[15] BLB[15] VDD GND sram_bitcell
Xbit_r46_c16 WL[46] BL[16] BLB[16] VDD GND sram_bitcell
Xbit_r46_c17 WL[46] BL[17] BLB[17] VDD GND sram_bitcell
Xbit_r46_c18 WL[46] BL[18] BLB[18] VDD GND sram_bitcell
Xbit_r46_c19 WL[46] BL[19] BLB[19] VDD GND sram_bitcell
Xbit_r46_c20 WL[46] BL[20] BLB[20] VDD GND sram_bitcell
Xbit_r46_c21 WL[46] BL[21] BLB[21] VDD GND sram_bitcell
Xbit_r46_c22 WL[46] BL[22] BLB[22] VDD GND sram_bitcell
Xbit_r46_c23 WL[46] BL[23] BLB[23] VDD GND sram_bitcell
Xbit_r46_c24 WL[46] BL[24] BLB[24] VDD GND sram_bitcell
Xbit_r46_c25 WL[46] BL[25] BLB[25] VDD GND sram_bitcell
Xbit_r46_c26 WL[46] BL[26] BLB[26] VDD GND sram_bitcell
Xbit_r46_c27 WL[46] BL[27] BLB[27] VDD GND sram_bitcell
Xbit_r46_c28 WL[46] BL[28] BLB[28] VDD GND sram_bitcell
Xbit_r46_c29 WL[46] BL[29] BLB[29] VDD GND sram_bitcell
Xbit_r46_c30 WL[46] BL[30] BLB[30] VDD GND sram_bitcell
Xbit_r46_c31 WL[46] BL[31] BLB[31] VDD GND sram_bitcell
Xbit_r47_c0 WL[47] BL[0] BLB[0] VDD GND sram_bitcell
Xbit_r47_c1 WL[47] BL[1] BLB[1] VDD GND sram_bitcell
Xbit_r47_c2 WL[47] BL[2] BLB[2] VDD GND sram_bitcell
Xbit_r47_c3 WL[47] BL[3] BLB[3] VDD GND sram_bitcell
Xbit_r47_c4 WL[47] BL[4] BLB[4] VDD GND sram_bitcell
Xbit_r47_c5 WL[47] BL[5] BLB[5] VDD GND sram_bitcell
Xbit_r47_c6 WL[47] BL[6] BLB[6] VDD GND sram_bitcell
Xbit_r47_c7 WL[47] BL[7] BLB[7] VDD GND sram_bitcell
Xbit_r47_c8 WL[47] BL[8] BLB[8] VDD GND sram_bitcell
Xbit_r47_c9 WL[47] BL[9] BLB[9] VDD GND sram_bitcell
Xbit_r47_c10 WL[47] BL[10] BLB[10] VDD GND sram_bitcell
Xbit_r47_c11 WL[47] BL[11] BLB[11] VDD GND sram_bitcell
Xbit_r47_c12 WL[47] BL[12] BLB[12] VDD GND sram_bitcell
Xbit_r47_c13 WL[47] BL[13] BLB[13] VDD GND sram_bitcell
Xbit_r47_c14 WL[47] BL[14] BLB[14] VDD GND sram_bitcell
Xbit_r47_c15 WL[47] BL[15] BLB[15] VDD GND sram_bitcell
Xbit_r47_c16 WL[47] BL[16] BLB[16] VDD GND sram_bitcell
Xbit_r47_c17 WL[47] BL[17] BLB[17] VDD GND sram_bitcell
Xbit_r47_c18 WL[47] BL[18] BLB[18] VDD GND sram_bitcell
Xbit_r47_c19 WL[47] BL[19] BLB[19] VDD GND sram_bitcell
Xbit_r47_c20 WL[47] BL[20] BLB[20] VDD GND sram_bitcell
Xbit_r47_c21 WL[47] BL[21] BLB[21] VDD GND sram_bitcell
Xbit_r47_c22 WL[47] BL[22] BLB[22] VDD GND sram_bitcell
Xbit_r47_c23 WL[47] BL[23] BLB[23] VDD GND sram_bitcell
Xbit_r47_c24 WL[47] BL[24] BLB[24] VDD GND sram_bitcell
Xbit_r47_c25 WL[47] BL[25] BLB[25] VDD GND sram_bitcell
Xbit_r47_c26 WL[47] BL[26] BLB[26] VDD GND sram_bitcell
Xbit_r47_c27 WL[47] BL[27] BLB[27] VDD GND sram_bitcell
Xbit_r47_c28 WL[47] BL[28] BLB[28] VDD GND sram_bitcell
Xbit_r47_c29 WL[47] BL[29] BLB[29] VDD GND sram_bitcell
Xbit_r47_c30 WL[47] BL[30] BLB[30] VDD GND sram_bitcell
Xbit_r47_c31 WL[47] BL[31] BLB[31] VDD GND sram_bitcell
Xbit_r48_c0 WL[48] BL[0] BLB[0] VDD GND sram_bitcell
Xbit_r48_c1 WL[48] BL[1] BLB[1] VDD GND sram_bitcell
Xbit_r48_c2 WL[48] BL[2] BLB[2] VDD GND sram_bitcell
Xbit_r48_c3 WL[48] BL[3] BLB[3] VDD GND sram_bitcell
Xbit_r48_c4 WL[48] BL[4] BLB[4] VDD GND sram_bitcell
Xbit_r48_c5 WL[48] BL[5] BLB[5] VDD GND sram_bitcell
Xbit_r48_c6 WL[48] BL[6] BLB[6] VDD GND sram_bitcell
Xbit_r48_c7 WL[48] BL[7] BLB[7] VDD GND sram_bitcell
Xbit_r48_c8 WL[48] BL[8] BLB[8] VDD GND sram_bitcell
Xbit_r48_c9 WL[48] BL[9] BLB[9] VDD GND sram_bitcell
Xbit_r48_c10 WL[48] BL[10] BLB[10] VDD GND sram_bitcell
Xbit_r48_c11 WL[48] BL[11] BLB[11] VDD GND sram_bitcell
Xbit_r48_c12 WL[48] BL[12] BLB[12] VDD GND sram_bitcell
Xbit_r48_c13 WL[48] BL[13] BLB[13] VDD GND sram_bitcell
Xbit_r48_c14 WL[48] BL[14] BLB[14] VDD GND sram_bitcell
Xbit_r48_c15 WL[48] BL[15] BLB[15] VDD GND sram_bitcell
Xbit_r48_c16 WL[48] BL[16] BLB[16] VDD GND sram_bitcell
Xbit_r48_c17 WL[48] BL[17] BLB[17] VDD GND sram_bitcell
Xbit_r48_c18 WL[48] BL[18] BLB[18] VDD GND sram_bitcell
Xbit_r48_c19 WL[48] BL[19] BLB[19] VDD GND sram_bitcell
Xbit_r48_c20 WL[48] BL[20] BLB[20] VDD GND sram_bitcell
Xbit_r48_c21 WL[48] BL[21] BLB[21] VDD GND sram_bitcell
Xbit_r48_c22 WL[48] BL[22] BLB[22] VDD GND sram_bitcell
Xbit_r48_c23 WL[48] BL[23] BLB[23] VDD GND sram_bitcell
Xbit_r48_c24 WL[48] BL[24] BLB[24] VDD GND sram_bitcell
Xbit_r48_c25 WL[48] BL[25] BLB[25] VDD GND sram_bitcell
Xbit_r48_c26 WL[48] BL[26] BLB[26] VDD GND sram_bitcell
Xbit_r48_c27 WL[48] BL[27] BLB[27] VDD GND sram_bitcell
Xbit_r48_c28 WL[48] BL[28] BLB[28] VDD GND sram_bitcell
Xbit_r48_c29 WL[48] BL[29] BLB[29] VDD GND sram_bitcell
Xbit_r48_c30 WL[48] BL[30] BLB[30] VDD GND sram_bitcell
Xbit_r48_c31 WL[48] BL[31] BLB[31] VDD GND sram_bitcell
Xbit_r49_c0 WL[49] BL[0] BLB[0] VDD GND sram_bitcell
Xbit_r49_c1 WL[49] BL[1] BLB[1] VDD GND sram_bitcell
Xbit_r49_c2 WL[49] BL[2] BLB[2] VDD GND sram_bitcell
Xbit_r49_c3 WL[49] BL[3] BLB[3] VDD GND sram_bitcell
Xbit_r49_c4 WL[49] BL[4] BLB[4] VDD GND sram_bitcell
Xbit_r49_c5 WL[49] BL[5] BLB[5] VDD GND sram_bitcell
Xbit_r49_c6 WL[49] BL[6] BLB[6] VDD GND sram_bitcell
Xbit_r49_c7 WL[49] BL[7] BLB[7] VDD GND sram_bitcell
Xbit_r49_c8 WL[49] BL[8] BLB[8] VDD GND sram_bitcell
Xbit_r49_c9 WL[49] BL[9] BLB[9] VDD GND sram_bitcell
Xbit_r49_c10 WL[49] BL[10] BLB[10] VDD GND sram_bitcell
Xbit_r49_c11 WL[49] BL[11] BLB[11] VDD GND sram_bitcell
Xbit_r49_c12 WL[49] BL[12] BLB[12] VDD GND sram_bitcell
Xbit_r49_c13 WL[49] BL[13] BLB[13] VDD GND sram_bitcell
Xbit_r49_c14 WL[49] BL[14] BLB[14] VDD GND sram_bitcell
Xbit_r49_c15 WL[49] BL[15] BLB[15] VDD GND sram_bitcell
Xbit_r49_c16 WL[49] BL[16] BLB[16] VDD GND sram_bitcell
Xbit_r49_c17 WL[49] BL[17] BLB[17] VDD GND sram_bitcell
Xbit_r49_c18 WL[49] BL[18] BLB[18] VDD GND sram_bitcell
Xbit_r49_c19 WL[49] BL[19] BLB[19] VDD GND sram_bitcell
Xbit_r49_c20 WL[49] BL[20] BLB[20] VDD GND sram_bitcell
Xbit_r49_c21 WL[49] BL[21] BLB[21] VDD GND sram_bitcell
Xbit_r49_c22 WL[49] BL[22] BLB[22] VDD GND sram_bitcell
Xbit_r49_c23 WL[49] BL[23] BLB[23] VDD GND sram_bitcell
Xbit_r49_c24 WL[49] BL[24] BLB[24] VDD GND sram_bitcell
Xbit_r49_c25 WL[49] BL[25] BLB[25] VDD GND sram_bitcell
Xbit_r49_c26 WL[49] BL[26] BLB[26] VDD GND sram_bitcell
Xbit_r49_c27 WL[49] BL[27] BLB[27] VDD GND sram_bitcell
Xbit_r49_c28 WL[49] BL[28] BLB[28] VDD GND sram_bitcell
Xbit_r49_c29 WL[49] BL[29] BLB[29] VDD GND sram_bitcell
Xbit_r49_c30 WL[49] BL[30] BLB[30] VDD GND sram_bitcell
Xbit_r49_c31 WL[49] BL[31] BLB[31] VDD GND sram_bitcell
Xbit_r50_c0 WL[50] BL[0] BLB[0] VDD GND sram_bitcell
Xbit_r50_c1 WL[50] BL[1] BLB[1] VDD GND sram_bitcell
Xbit_r50_c2 WL[50] BL[2] BLB[2] VDD GND sram_bitcell
Xbit_r50_c3 WL[50] BL[3] BLB[3] VDD GND sram_bitcell
Xbit_r50_c4 WL[50] BL[4] BLB[4] VDD GND sram_bitcell
Xbit_r50_c5 WL[50] BL[5] BLB[5] VDD GND sram_bitcell
Xbit_r50_c6 WL[50] BL[6] BLB[6] VDD GND sram_bitcell
Xbit_r50_c7 WL[50] BL[7] BLB[7] VDD GND sram_bitcell
Xbit_r50_c8 WL[50] BL[8] BLB[8] VDD GND sram_bitcell
Xbit_r50_c9 WL[50] BL[9] BLB[9] VDD GND sram_bitcell
Xbit_r50_c10 WL[50] BL[10] BLB[10] VDD GND sram_bitcell
Xbit_r50_c11 WL[50] BL[11] BLB[11] VDD GND sram_bitcell
Xbit_r50_c12 WL[50] BL[12] BLB[12] VDD GND sram_bitcell
Xbit_r50_c13 WL[50] BL[13] BLB[13] VDD GND sram_bitcell
Xbit_r50_c14 WL[50] BL[14] BLB[14] VDD GND sram_bitcell
Xbit_r50_c15 WL[50] BL[15] BLB[15] VDD GND sram_bitcell
Xbit_r50_c16 WL[50] BL[16] BLB[16] VDD GND sram_bitcell
Xbit_r50_c17 WL[50] BL[17] BLB[17] VDD GND sram_bitcell
Xbit_r50_c18 WL[50] BL[18] BLB[18] VDD GND sram_bitcell
Xbit_r50_c19 WL[50] BL[19] BLB[19] VDD GND sram_bitcell
Xbit_r50_c20 WL[50] BL[20] BLB[20] VDD GND sram_bitcell
Xbit_r50_c21 WL[50] BL[21] BLB[21] VDD GND sram_bitcell
Xbit_r50_c22 WL[50] BL[22] BLB[22] VDD GND sram_bitcell
Xbit_r50_c23 WL[50] BL[23] BLB[23] VDD GND sram_bitcell
Xbit_r50_c24 WL[50] BL[24] BLB[24] VDD GND sram_bitcell
Xbit_r50_c25 WL[50] BL[25] BLB[25] VDD GND sram_bitcell
Xbit_r50_c26 WL[50] BL[26] BLB[26] VDD GND sram_bitcell
Xbit_r50_c27 WL[50] BL[27] BLB[27] VDD GND sram_bitcell
Xbit_r50_c28 WL[50] BL[28] BLB[28] VDD GND sram_bitcell
Xbit_r50_c29 WL[50] BL[29] BLB[29] VDD GND sram_bitcell
Xbit_r50_c30 WL[50] BL[30] BLB[30] VDD GND sram_bitcell
Xbit_r50_c31 WL[50] BL[31] BLB[31] VDD GND sram_bitcell
Xbit_r51_c0 WL[51] BL[0] BLB[0] VDD GND sram_bitcell
Xbit_r51_c1 WL[51] BL[1] BLB[1] VDD GND sram_bitcell
Xbit_r51_c2 WL[51] BL[2] BLB[2] VDD GND sram_bitcell
Xbit_r51_c3 WL[51] BL[3] BLB[3] VDD GND sram_bitcell
Xbit_r51_c4 WL[51] BL[4] BLB[4] VDD GND sram_bitcell
Xbit_r51_c5 WL[51] BL[5] BLB[5] VDD GND sram_bitcell
Xbit_r51_c6 WL[51] BL[6] BLB[6] VDD GND sram_bitcell
Xbit_r51_c7 WL[51] BL[7] BLB[7] VDD GND sram_bitcell
Xbit_r51_c8 WL[51] BL[8] BLB[8] VDD GND sram_bitcell
Xbit_r51_c9 WL[51] BL[9] BLB[9] VDD GND sram_bitcell
Xbit_r51_c10 WL[51] BL[10] BLB[10] VDD GND sram_bitcell
Xbit_r51_c11 WL[51] BL[11] BLB[11] VDD GND sram_bitcell
Xbit_r51_c12 WL[51] BL[12] BLB[12] VDD GND sram_bitcell
Xbit_r51_c13 WL[51] BL[13] BLB[13] VDD GND sram_bitcell
Xbit_r51_c14 WL[51] BL[14] BLB[14] VDD GND sram_bitcell
Xbit_r51_c15 WL[51] BL[15] BLB[15] VDD GND sram_bitcell
Xbit_r51_c16 WL[51] BL[16] BLB[16] VDD GND sram_bitcell
Xbit_r51_c17 WL[51] BL[17] BLB[17] VDD GND sram_bitcell
Xbit_r51_c18 WL[51] BL[18] BLB[18] VDD GND sram_bitcell
Xbit_r51_c19 WL[51] BL[19] BLB[19] VDD GND sram_bitcell
Xbit_r51_c20 WL[51] BL[20] BLB[20] VDD GND sram_bitcell
Xbit_r51_c21 WL[51] BL[21] BLB[21] VDD GND sram_bitcell
Xbit_r51_c22 WL[51] BL[22] BLB[22] VDD GND sram_bitcell
Xbit_r51_c23 WL[51] BL[23] BLB[23] VDD GND sram_bitcell
Xbit_r51_c24 WL[51] BL[24] BLB[24] VDD GND sram_bitcell
Xbit_r51_c25 WL[51] BL[25] BLB[25] VDD GND sram_bitcell
Xbit_r51_c26 WL[51] BL[26] BLB[26] VDD GND sram_bitcell
Xbit_r51_c27 WL[51] BL[27] BLB[27] VDD GND sram_bitcell
Xbit_r51_c28 WL[51] BL[28] BLB[28] VDD GND sram_bitcell
Xbit_r51_c29 WL[51] BL[29] BLB[29] VDD GND sram_bitcell
Xbit_r51_c30 WL[51] BL[30] BLB[30] VDD GND sram_bitcell
Xbit_r51_c31 WL[51] BL[31] BLB[31] VDD GND sram_bitcell
Xbit_r52_c0 WL[52] BL[0] BLB[0] VDD GND sram_bitcell
Xbit_r52_c1 WL[52] BL[1] BLB[1] VDD GND sram_bitcell
Xbit_r52_c2 WL[52] BL[2] BLB[2] VDD GND sram_bitcell
Xbit_r52_c3 WL[52] BL[3] BLB[3] VDD GND sram_bitcell
Xbit_r52_c4 WL[52] BL[4] BLB[4] VDD GND sram_bitcell
Xbit_r52_c5 WL[52] BL[5] BLB[5] VDD GND sram_bitcell
Xbit_r52_c6 WL[52] BL[6] BLB[6] VDD GND sram_bitcell
Xbit_r52_c7 WL[52] BL[7] BLB[7] VDD GND sram_bitcell
Xbit_r52_c8 WL[52] BL[8] BLB[8] VDD GND sram_bitcell
Xbit_r52_c9 WL[52] BL[9] BLB[9] VDD GND sram_bitcell
Xbit_r52_c10 WL[52] BL[10] BLB[10] VDD GND sram_bitcell
Xbit_r52_c11 WL[52] BL[11] BLB[11] VDD GND sram_bitcell
Xbit_r52_c12 WL[52] BL[12] BLB[12] VDD GND sram_bitcell
Xbit_r52_c13 WL[52] BL[13] BLB[13] VDD GND sram_bitcell
Xbit_r52_c14 WL[52] BL[14] BLB[14] VDD GND sram_bitcell
Xbit_r52_c15 WL[52] BL[15] BLB[15] VDD GND sram_bitcell
Xbit_r52_c16 WL[52] BL[16] BLB[16] VDD GND sram_bitcell
Xbit_r52_c17 WL[52] BL[17] BLB[17] VDD GND sram_bitcell
Xbit_r52_c18 WL[52] BL[18] BLB[18] VDD GND sram_bitcell
Xbit_r52_c19 WL[52] BL[19] BLB[19] VDD GND sram_bitcell
Xbit_r52_c20 WL[52] BL[20] BLB[20] VDD GND sram_bitcell
Xbit_r52_c21 WL[52] BL[21] BLB[21] VDD GND sram_bitcell
Xbit_r52_c22 WL[52] BL[22] BLB[22] VDD GND sram_bitcell
Xbit_r52_c23 WL[52] BL[23] BLB[23] VDD GND sram_bitcell
Xbit_r52_c24 WL[52] BL[24] BLB[24] VDD GND sram_bitcell
Xbit_r52_c25 WL[52] BL[25] BLB[25] VDD GND sram_bitcell
Xbit_r52_c26 WL[52] BL[26] BLB[26] VDD GND sram_bitcell
Xbit_r52_c27 WL[52] BL[27] BLB[27] VDD GND sram_bitcell
Xbit_r52_c28 WL[52] BL[28] BLB[28] VDD GND sram_bitcell
Xbit_r52_c29 WL[52] BL[29] BLB[29] VDD GND sram_bitcell
Xbit_r52_c30 WL[52] BL[30] BLB[30] VDD GND sram_bitcell
Xbit_r52_c31 WL[52] BL[31] BLB[31] VDD GND sram_bitcell
Xbit_r53_c0 WL[53] BL[0] BLB[0] VDD GND sram_bitcell
Xbit_r53_c1 WL[53] BL[1] BLB[1] VDD GND sram_bitcell
Xbit_r53_c2 WL[53] BL[2] BLB[2] VDD GND sram_bitcell
Xbit_r53_c3 WL[53] BL[3] BLB[3] VDD GND sram_bitcell
Xbit_r53_c4 WL[53] BL[4] BLB[4] VDD GND sram_bitcell
Xbit_r53_c5 WL[53] BL[5] BLB[5] VDD GND sram_bitcell
Xbit_r53_c6 WL[53] BL[6] BLB[6] VDD GND sram_bitcell
Xbit_r53_c7 WL[53] BL[7] BLB[7] VDD GND sram_bitcell
Xbit_r53_c8 WL[53] BL[8] BLB[8] VDD GND sram_bitcell
Xbit_r53_c9 WL[53] BL[9] BLB[9] VDD GND sram_bitcell
Xbit_r53_c10 WL[53] BL[10] BLB[10] VDD GND sram_bitcell
Xbit_r53_c11 WL[53] BL[11] BLB[11] VDD GND sram_bitcell
Xbit_r53_c12 WL[53] BL[12] BLB[12] VDD GND sram_bitcell
Xbit_r53_c13 WL[53] BL[13] BLB[13] VDD GND sram_bitcell
Xbit_r53_c14 WL[53] BL[14] BLB[14] VDD GND sram_bitcell
Xbit_r53_c15 WL[53] BL[15] BLB[15] VDD GND sram_bitcell
Xbit_r53_c16 WL[53] BL[16] BLB[16] VDD GND sram_bitcell
Xbit_r53_c17 WL[53] BL[17] BLB[17] VDD GND sram_bitcell
Xbit_r53_c18 WL[53] BL[18] BLB[18] VDD GND sram_bitcell
Xbit_r53_c19 WL[53] BL[19] BLB[19] VDD GND sram_bitcell
Xbit_r53_c20 WL[53] BL[20] BLB[20] VDD GND sram_bitcell
Xbit_r53_c21 WL[53] BL[21] BLB[21] VDD GND sram_bitcell
Xbit_r53_c22 WL[53] BL[22] BLB[22] VDD GND sram_bitcell
Xbit_r53_c23 WL[53] BL[23] BLB[23] VDD GND sram_bitcell
Xbit_r53_c24 WL[53] BL[24] BLB[24] VDD GND sram_bitcell
Xbit_r53_c25 WL[53] BL[25] BLB[25] VDD GND sram_bitcell
Xbit_r53_c26 WL[53] BL[26] BLB[26] VDD GND sram_bitcell
Xbit_r53_c27 WL[53] BL[27] BLB[27] VDD GND sram_bitcell
Xbit_r53_c28 WL[53] BL[28] BLB[28] VDD GND sram_bitcell
Xbit_r53_c29 WL[53] BL[29] BLB[29] VDD GND sram_bitcell
Xbit_r53_c30 WL[53] BL[30] BLB[30] VDD GND sram_bitcell
Xbit_r53_c31 WL[53] BL[31] BLB[31] VDD GND sram_bitcell
Xbit_r54_c0 WL[54] BL[0] BLB[0] VDD GND sram_bitcell
Xbit_r54_c1 WL[54] BL[1] BLB[1] VDD GND sram_bitcell
Xbit_r54_c2 WL[54] BL[2] BLB[2] VDD GND sram_bitcell
Xbit_r54_c3 WL[54] BL[3] BLB[3] VDD GND sram_bitcell
Xbit_r54_c4 WL[54] BL[4] BLB[4] VDD GND sram_bitcell
Xbit_r54_c5 WL[54] BL[5] BLB[5] VDD GND sram_bitcell
Xbit_r54_c6 WL[54] BL[6] BLB[6] VDD GND sram_bitcell
Xbit_r54_c7 WL[54] BL[7] BLB[7] VDD GND sram_bitcell
Xbit_r54_c8 WL[54] BL[8] BLB[8] VDD GND sram_bitcell
Xbit_r54_c9 WL[54] BL[9] BLB[9] VDD GND sram_bitcell
Xbit_r54_c10 WL[54] BL[10] BLB[10] VDD GND sram_bitcell
Xbit_r54_c11 WL[54] BL[11] BLB[11] VDD GND sram_bitcell
Xbit_r54_c12 WL[54] BL[12] BLB[12] VDD GND sram_bitcell
Xbit_r54_c13 WL[54] BL[13] BLB[13] VDD GND sram_bitcell
Xbit_r54_c14 WL[54] BL[14] BLB[14] VDD GND sram_bitcell
Xbit_r54_c15 WL[54] BL[15] BLB[15] VDD GND sram_bitcell
Xbit_r54_c16 WL[54] BL[16] BLB[16] VDD GND sram_bitcell
Xbit_r54_c17 WL[54] BL[17] BLB[17] VDD GND sram_bitcell
Xbit_r54_c18 WL[54] BL[18] BLB[18] VDD GND sram_bitcell
Xbit_r54_c19 WL[54] BL[19] BLB[19] VDD GND sram_bitcell
Xbit_r54_c20 WL[54] BL[20] BLB[20] VDD GND sram_bitcell
Xbit_r54_c21 WL[54] BL[21] BLB[21] VDD GND sram_bitcell
Xbit_r54_c22 WL[54] BL[22] BLB[22] VDD GND sram_bitcell
Xbit_r54_c23 WL[54] BL[23] BLB[23] VDD GND sram_bitcell
Xbit_r54_c24 WL[54] BL[24] BLB[24] VDD GND sram_bitcell
Xbit_r54_c25 WL[54] BL[25] BLB[25] VDD GND sram_bitcell
Xbit_r54_c26 WL[54] BL[26] BLB[26] VDD GND sram_bitcell
Xbit_r54_c27 WL[54] BL[27] BLB[27] VDD GND sram_bitcell
Xbit_r54_c28 WL[54] BL[28] BLB[28] VDD GND sram_bitcell
Xbit_r54_c29 WL[54] BL[29] BLB[29] VDD GND sram_bitcell
Xbit_r54_c30 WL[54] BL[30] BLB[30] VDD GND sram_bitcell
Xbit_r54_c31 WL[54] BL[31] BLB[31] VDD GND sram_bitcell
Xbit_r55_c0 WL[55] BL[0] BLB[0] VDD GND sram_bitcell
Xbit_r55_c1 WL[55] BL[1] BLB[1] VDD GND sram_bitcell
Xbit_r55_c2 WL[55] BL[2] BLB[2] VDD GND sram_bitcell
Xbit_r55_c3 WL[55] BL[3] BLB[3] VDD GND sram_bitcell
Xbit_r55_c4 WL[55] BL[4] BLB[4] VDD GND sram_bitcell
Xbit_r55_c5 WL[55] BL[5] BLB[5] VDD GND sram_bitcell
Xbit_r55_c6 WL[55] BL[6] BLB[6] VDD GND sram_bitcell
Xbit_r55_c7 WL[55] BL[7] BLB[7] VDD GND sram_bitcell
Xbit_r55_c8 WL[55] BL[8] BLB[8] VDD GND sram_bitcell
Xbit_r55_c9 WL[55] BL[9] BLB[9] VDD GND sram_bitcell
Xbit_r55_c10 WL[55] BL[10] BLB[10] VDD GND sram_bitcell
Xbit_r55_c11 WL[55] BL[11] BLB[11] VDD GND sram_bitcell
Xbit_r55_c12 WL[55] BL[12] BLB[12] VDD GND sram_bitcell
Xbit_r55_c13 WL[55] BL[13] BLB[13] VDD GND sram_bitcell
Xbit_r55_c14 WL[55] BL[14] BLB[14] VDD GND sram_bitcell
Xbit_r55_c15 WL[55] BL[15] BLB[15] VDD GND sram_bitcell
Xbit_r55_c16 WL[55] BL[16] BLB[16] VDD GND sram_bitcell
Xbit_r55_c17 WL[55] BL[17] BLB[17] VDD GND sram_bitcell
Xbit_r55_c18 WL[55] BL[18] BLB[18] VDD GND sram_bitcell
Xbit_r55_c19 WL[55] BL[19] BLB[19] VDD GND sram_bitcell
Xbit_r55_c20 WL[55] BL[20] BLB[20] VDD GND sram_bitcell
Xbit_r55_c21 WL[55] BL[21] BLB[21] VDD GND sram_bitcell
Xbit_r55_c22 WL[55] BL[22] BLB[22] VDD GND sram_bitcell
Xbit_r55_c23 WL[55] BL[23] BLB[23] VDD GND sram_bitcell
Xbit_r55_c24 WL[55] BL[24] BLB[24] VDD GND sram_bitcell
Xbit_r55_c25 WL[55] BL[25] BLB[25] VDD GND sram_bitcell
Xbit_r55_c26 WL[55] BL[26] BLB[26] VDD GND sram_bitcell
Xbit_r55_c27 WL[55] BL[27] BLB[27] VDD GND sram_bitcell
Xbit_r55_c28 WL[55] BL[28] BLB[28] VDD GND sram_bitcell
Xbit_r55_c29 WL[55] BL[29] BLB[29] VDD GND sram_bitcell
Xbit_r55_c30 WL[55] BL[30] BLB[30] VDD GND sram_bitcell
Xbit_r55_c31 WL[55] BL[31] BLB[31] VDD GND sram_bitcell
Xbit_r56_c0 WL[56] BL[0] BLB[0] VDD GND sram_bitcell
Xbit_r56_c1 WL[56] BL[1] BLB[1] VDD GND sram_bitcell
Xbit_r56_c2 WL[56] BL[2] BLB[2] VDD GND sram_bitcell
Xbit_r56_c3 WL[56] BL[3] BLB[3] VDD GND sram_bitcell
Xbit_r56_c4 WL[56] BL[4] BLB[4] VDD GND sram_bitcell
Xbit_r56_c5 WL[56] BL[5] BLB[5] VDD GND sram_bitcell
Xbit_r56_c6 WL[56] BL[6] BLB[6] VDD GND sram_bitcell
Xbit_r56_c7 WL[56] BL[7] BLB[7] VDD GND sram_bitcell
Xbit_r56_c8 WL[56] BL[8] BLB[8] VDD GND sram_bitcell
Xbit_r56_c9 WL[56] BL[9] BLB[9] VDD GND sram_bitcell
Xbit_r56_c10 WL[56] BL[10] BLB[10] VDD GND sram_bitcell
Xbit_r56_c11 WL[56] BL[11] BLB[11] VDD GND sram_bitcell
Xbit_r56_c12 WL[56] BL[12] BLB[12] VDD GND sram_bitcell
Xbit_r56_c13 WL[56] BL[13] BLB[13] VDD GND sram_bitcell
Xbit_r56_c14 WL[56] BL[14] BLB[14] VDD GND sram_bitcell
Xbit_r56_c15 WL[56] BL[15] BLB[15] VDD GND sram_bitcell
Xbit_r56_c16 WL[56] BL[16] BLB[16] VDD GND sram_bitcell
Xbit_r56_c17 WL[56] BL[17] BLB[17] VDD GND sram_bitcell
Xbit_r56_c18 WL[56] BL[18] BLB[18] VDD GND sram_bitcell
Xbit_r56_c19 WL[56] BL[19] BLB[19] VDD GND sram_bitcell
Xbit_r56_c20 WL[56] BL[20] BLB[20] VDD GND sram_bitcell
Xbit_r56_c21 WL[56] BL[21] BLB[21] VDD GND sram_bitcell
Xbit_r56_c22 WL[56] BL[22] BLB[22] VDD GND sram_bitcell
Xbit_r56_c23 WL[56] BL[23] BLB[23] VDD GND sram_bitcell
Xbit_r56_c24 WL[56] BL[24] BLB[24] VDD GND sram_bitcell
Xbit_r56_c25 WL[56] BL[25] BLB[25] VDD GND sram_bitcell
Xbit_r56_c26 WL[56] BL[26] BLB[26] VDD GND sram_bitcell
Xbit_r56_c27 WL[56] BL[27] BLB[27] VDD GND sram_bitcell
Xbit_r56_c28 WL[56] BL[28] BLB[28] VDD GND sram_bitcell
Xbit_r56_c29 WL[56] BL[29] BLB[29] VDD GND sram_bitcell
Xbit_r56_c30 WL[56] BL[30] BLB[30] VDD GND sram_bitcell
Xbit_r56_c31 WL[56] BL[31] BLB[31] VDD GND sram_bitcell
Xbit_r57_c0 WL[57] BL[0] BLB[0] VDD GND sram_bitcell
Xbit_r57_c1 WL[57] BL[1] BLB[1] VDD GND sram_bitcell
Xbit_r57_c2 WL[57] BL[2] BLB[2] VDD GND sram_bitcell
Xbit_r57_c3 WL[57] BL[3] BLB[3] VDD GND sram_bitcell
Xbit_r57_c4 WL[57] BL[4] BLB[4] VDD GND sram_bitcell
Xbit_r57_c5 WL[57] BL[5] BLB[5] VDD GND sram_bitcell
Xbit_r57_c6 WL[57] BL[6] BLB[6] VDD GND sram_bitcell
Xbit_r57_c7 WL[57] BL[7] BLB[7] VDD GND sram_bitcell
Xbit_r57_c8 WL[57] BL[8] BLB[8] VDD GND sram_bitcell
Xbit_r57_c9 WL[57] BL[9] BLB[9] VDD GND sram_bitcell
Xbit_r57_c10 WL[57] BL[10] BLB[10] VDD GND sram_bitcell
Xbit_r57_c11 WL[57] BL[11] BLB[11] VDD GND sram_bitcell
Xbit_r57_c12 WL[57] BL[12] BLB[12] VDD GND sram_bitcell
Xbit_r57_c13 WL[57] BL[13] BLB[13] VDD GND sram_bitcell
Xbit_r57_c14 WL[57] BL[14] BLB[14] VDD GND sram_bitcell
Xbit_r57_c15 WL[57] BL[15] BLB[15] VDD GND sram_bitcell
Xbit_r57_c16 WL[57] BL[16] BLB[16] VDD GND sram_bitcell
Xbit_r57_c17 WL[57] BL[17] BLB[17] VDD GND sram_bitcell
Xbit_r57_c18 WL[57] BL[18] BLB[18] VDD GND sram_bitcell
Xbit_r57_c19 WL[57] BL[19] BLB[19] VDD GND sram_bitcell
Xbit_r57_c20 WL[57] BL[20] BLB[20] VDD GND sram_bitcell
Xbit_r57_c21 WL[57] BL[21] BLB[21] VDD GND sram_bitcell
Xbit_r57_c22 WL[57] BL[22] BLB[22] VDD GND sram_bitcell
Xbit_r57_c23 WL[57] BL[23] BLB[23] VDD GND sram_bitcell
Xbit_r57_c24 WL[57] BL[24] BLB[24] VDD GND sram_bitcell
Xbit_r57_c25 WL[57] BL[25] BLB[25] VDD GND sram_bitcell
Xbit_r57_c26 WL[57] BL[26] BLB[26] VDD GND sram_bitcell
Xbit_r57_c27 WL[57] BL[27] BLB[27] VDD GND sram_bitcell
Xbit_r57_c28 WL[57] BL[28] BLB[28] VDD GND sram_bitcell
Xbit_r57_c29 WL[57] BL[29] BLB[29] VDD GND sram_bitcell
Xbit_r57_c30 WL[57] BL[30] BLB[30] VDD GND sram_bitcell
Xbit_r57_c31 WL[57] BL[31] BLB[31] VDD GND sram_bitcell
Xbit_r58_c0 WL[58] BL[0] BLB[0] VDD GND sram_bitcell
Xbit_r58_c1 WL[58] BL[1] BLB[1] VDD GND sram_bitcell
Xbit_r58_c2 WL[58] BL[2] BLB[2] VDD GND sram_bitcell
Xbit_r58_c3 WL[58] BL[3] BLB[3] VDD GND sram_bitcell
Xbit_r58_c4 WL[58] BL[4] BLB[4] VDD GND sram_bitcell
Xbit_r58_c5 WL[58] BL[5] BLB[5] VDD GND sram_bitcell
Xbit_r58_c6 WL[58] BL[6] BLB[6] VDD GND sram_bitcell
Xbit_r58_c7 WL[58] BL[7] BLB[7] VDD GND sram_bitcell
Xbit_r58_c8 WL[58] BL[8] BLB[8] VDD GND sram_bitcell
Xbit_r58_c9 WL[58] BL[9] BLB[9] VDD GND sram_bitcell
Xbit_r58_c10 WL[58] BL[10] BLB[10] VDD GND sram_bitcell
Xbit_r58_c11 WL[58] BL[11] BLB[11] VDD GND sram_bitcell
Xbit_r58_c12 WL[58] BL[12] BLB[12] VDD GND sram_bitcell
Xbit_r58_c13 WL[58] BL[13] BLB[13] VDD GND sram_bitcell
Xbit_r58_c14 WL[58] BL[14] BLB[14] VDD GND sram_bitcell
Xbit_r58_c15 WL[58] BL[15] BLB[15] VDD GND sram_bitcell
Xbit_r58_c16 WL[58] BL[16] BLB[16] VDD GND sram_bitcell
Xbit_r58_c17 WL[58] BL[17] BLB[17] VDD GND sram_bitcell
Xbit_r58_c18 WL[58] BL[18] BLB[18] VDD GND sram_bitcell
Xbit_r58_c19 WL[58] BL[19] BLB[19] VDD GND sram_bitcell
Xbit_r58_c20 WL[58] BL[20] BLB[20] VDD GND sram_bitcell
Xbit_r58_c21 WL[58] BL[21] BLB[21] VDD GND sram_bitcell
Xbit_r58_c22 WL[58] BL[22] BLB[22] VDD GND sram_bitcell
Xbit_r58_c23 WL[58] BL[23] BLB[23] VDD GND sram_bitcell
Xbit_r58_c24 WL[58] BL[24] BLB[24] VDD GND sram_bitcell
Xbit_r58_c25 WL[58] BL[25] BLB[25] VDD GND sram_bitcell
Xbit_r58_c26 WL[58] BL[26] BLB[26] VDD GND sram_bitcell
Xbit_r58_c27 WL[58] BL[27] BLB[27] VDD GND sram_bitcell
Xbit_r58_c28 WL[58] BL[28] BLB[28] VDD GND sram_bitcell
Xbit_r58_c29 WL[58] BL[29] BLB[29] VDD GND sram_bitcell
Xbit_r58_c30 WL[58] BL[30] BLB[30] VDD GND sram_bitcell
Xbit_r58_c31 WL[58] BL[31] BLB[31] VDD GND sram_bitcell
Xbit_r59_c0 WL[59] BL[0] BLB[0] VDD GND sram_bitcell
Xbit_r59_c1 WL[59] BL[1] BLB[1] VDD GND sram_bitcell
Xbit_r59_c2 WL[59] BL[2] BLB[2] VDD GND sram_bitcell
Xbit_r59_c3 WL[59] BL[3] BLB[3] VDD GND sram_bitcell
Xbit_r59_c4 WL[59] BL[4] BLB[4] VDD GND sram_bitcell
Xbit_r59_c5 WL[59] BL[5] BLB[5] VDD GND sram_bitcell
Xbit_r59_c6 WL[59] BL[6] BLB[6] VDD GND sram_bitcell
Xbit_r59_c7 WL[59] BL[7] BLB[7] VDD GND sram_bitcell
Xbit_r59_c8 WL[59] BL[8] BLB[8] VDD GND sram_bitcell
Xbit_r59_c9 WL[59] BL[9] BLB[9] VDD GND sram_bitcell
Xbit_r59_c10 WL[59] BL[10] BLB[10] VDD GND sram_bitcell
Xbit_r59_c11 WL[59] BL[11] BLB[11] VDD GND sram_bitcell
Xbit_r59_c12 WL[59] BL[12] BLB[12] VDD GND sram_bitcell
Xbit_r59_c13 WL[59] BL[13] BLB[13] VDD GND sram_bitcell
Xbit_r59_c14 WL[59] BL[14] BLB[14] VDD GND sram_bitcell
Xbit_r59_c15 WL[59] BL[15] BLB[15] VDD GND sram_bitcell
Xbit_r59_c16 WL[59] BL[16] BLB[16] VDD GND sram_bitcell
Xbit_r59_c17 WL[59] BL[17] BLB[17] VDD GND sram_bitcell
Xbit_r59_c18 WL[59] BL[18] BLB[18] VDD GND sram_bitcell
Xbit_r59_c19 WL[59] BL[19] BLB[19] VDD GND sram_bitcell
Xbit_r59_c20 WL[59] BL[20] BLB[20] VDD GND sram_bitcell
Xbit_r59_c21 WL[59] BL[21] BLB[21] VDD GND sram_bitcell
Xbit_r59_c22 WL[59] BL[22] BLB[22] VDD GND sram_bitcell
Xbit_r59_c23 WL[59] BL[23] BLB[23] VDD GND sram_bitcell
Xbit_r59_c24 WL[59] BL[24] BLB[24] VDD GND sram_bitcell
Xbit_r59_c25 WL[59] BL[25] BLB[25] VDD GND sram_bitcell
Xbit_r59_c26 WL[59] BL[26] BLB[26] VDD GND sram_bitcell
Xbit_r59_c27 WL[59] BL[27] BLB[27] VDD GND sram_bitcell
Xbit_r59_c28 WL[59] BL[28] BLB[28] VDD GND sram_bitcell
Xbit_r59_c29 WL[59] BL[29] BLB[29] VDD GND sram_bitcell
Xbit_r59_c30 WL[59] BL[30] BLB[30] VDD GND sram_bitcell
Xbit_r59_c31 WL[59] BL[31] BLB[31] VDD GND sram_bitcell
Xbit_r60_c0 WL[60] BL[0] BLB[0] VDD GND sram_bitcell
Xbit_r60_c1 WL[60] BL[1] BLB[1] VDD GND sram_bitcell
Xbit_r60_c2 WL[60] BL[2] BLB[2] VDD GND sram_bitcell
Xbit_r60_c3 WL[60] BL[3] BLB[3] VDD GND sram_bitcell
Xbit_r60_c4 WL[60] BL[4] BLB[4] VDD GND sram_bitcell
Xbit_r60_c5 WL[60] BL[5] BLB[5] VDD GND sram_bitcell
Xbit_r60_c6 WL[60] BL[6] BLB[6] VDD GND sram_bitcell
Xbit_r60_c7 WL[60] BL[7] BLB[7] VDD GND sram_bitcell
Xbit_r60_c8 WL[60] BL[8] BLB[8] VDD GND sram_bitcell
Xbit_r60_c9 WL[60] BL[9] BLB[9] VDD GND sram_bitcell
Xbit_r60_c10 WL[60] BL[10] BLB[10] VDD GND sram_bitcell
Xbit_r60_c11 WL[60] BL[11] BLB[11] VDD GND sram_bitcell
Xbit_r60_c12 WL[60] BL[12] BLB[12] VDD GND sram_bitcell
Xbit_r60_c13 WL[60] BL[13] BLB[13] VDD GND sram_bitcell
Xbit_r60_c14 WL[60] BL[14] BLB[14] VDD GND sram_bitcell
Xbit_r60_c15 WL[60] BL[15] BLB[15] VDD GND sram_bitcell
Xbit_r60_c16 WL[60] BL[16] BLB[16] VDD GND sram_bitcell
Xbit_r60_c17 WL[60] BL[17] BLB[17] VDD GND sram_bitcell
Xbit_r60_c18 WL[60] BL[18] BLB[18] VDD GND sram_bitcell
Xbit_r60_c19 WL[60] BL[19] BLB[19] VDD GND sram_bitcell
Xbit_r60_c20 WL[60] BL[20] BLB[20] VDD GND sram_bitcell
Xbit_r60_c21 WL[60] BL[21] BLB[21] VDD GND sram_bitcell
Xbit_r60_c22 WL[60] BL[22] BLB[22] VDD GND sram_bitcell
Xbit_r60_c23 WL[60] BL[23] BLB[23] VDD GND sram_bitcell
Xbit_r60_c24 WL[60] BL[24] BLB[24] VDD GND sram_bitcell
Xbit_r60_c25 WL[60] BL[25] BLB[25] VDD GND sram_bitcell
Xbit_r60_c26 WL[60] BL[26] BLB[26] VDD GND sram_bitcell
Xbit_r60_c27 WL[60] BL[27] BLB[27] VDD GND sram_bitcell
Xbit_r60_c28 WL[60] BL[28] BLB[28] VDD GND sram_bitcell
Xbit_r60_c29 WL[60] BL[29] BLB[29] VDD GND sram_bitcell
Xbit_r60_c30 WL[60] BL[30] BLB[30] VDD GND sram_bitcell
Xbit_r60_c31 WL[60] BL[31] BLB[31] VDD GND sram_bitcell
Xbit_r61_c0 WL[61] BL[0] BLB[0] VDD GND sram_bitcell
Xbit_r61_c1 WL[61] BL[1] BLB[1] VDD GND sram_bitcell
Xbit_r61_c2 WL[61] BL[2] BLB[2] VDD GND sram_bitcell
Xbit_r61_c3 WL[61] BL[3] BLB[3] VDD GND sram_bitcell
Xbit_r61_c4 WL[61] BL[4] BLB[4] VDD GND sram_bitcell
Xbit_r61_c5 WL[61] BL[5] BLB[5] VDD GND sram_bitcell
Xbit_r61_c6 WL[61] BL[6] BLB[6] VDD GND sram_bitcell
Xbit_r61_c7 WL[61] BL[7] BLB[7] VDD GND sram_bitcell
Xbit_r61_c8 WL[61] BL[8] BLB[8] VDD GND sram_bitcell
Xbit_r61_c9 WL[61] BL[9] BLB[9] VDD GND sram_bitcell
Xbit_r61_c10 WL[61] BL[10] BLB[10] VDD GND sram_bitcell
Xbit_r61_c11 WL[61] BL[11] BLB[11] VDD GND sram_bitcell
Xbit_r61_c12 WL[61] BL[12] BLB[12] VDD GND sram_bitcell
Xbit_r61_c13 WL[61] BL[13] BLB[13] VDD GND sram_bitcell
Xbit_r61_c14 WL[61] BL[14] BLB[14] VDD GND sram_bitcell
Xbit_r61_c15 WL[61] BL[15] BLB[15] VDD GND sram_bitcell
Xbit_r61_c16 WL[61] BL[16] BLB[16] VDD GND sram_bitcell
Xbit_r61_c17 WL[61] BL[17] BLB[17] VDD GND sram_bitcell
Xbit_r61_c18 WL[61] BL[18] BLB[18] VDD GND sram_bitcell
Xbit_r61_c19 WL[61] BL[19] BLB[19] VDD GND sram_bitcell
Xbit_r61_c20 WL[61] BL[20] BLB[20] VDD GND sram_bitcell
Xbit_r61_c21 WL[61] BL[21] BLB[21] VDD GND sram_bitcell
Xbit_r61_c22 WL[61] BL[22] BLB[22] VDD GND sram_bitcell
Xbit_r61_c23 WL[61] BL[23] BLB[23] VDD GND sram_bitcell
Xbit_r61_c24 WL[61] BL[24] BLB[24] VDD GND sram_bitcell
Xbit_r61_c25 WL[61] BL[25] BLB[25] VDD GND sram_bitcell
Xbit_r61_c26 WL[61] BL[26] BLB[26] VDD GND sram_bitcell
Xbit_r61_c27 WL[61] BL[27] BLB[27] VDD GND sram_bitcell
Xbit_r61_c28 WL[61] BL[28] BLB[28] VDD GND sram_bitcell
Xbit_r61_c29 WL[61] BL[29] BLB[29] VDD GND sram_bitcell
Xbit_r61_c30 WL[61] BL[30] BLB[30] VDD GND sram_bitcell
Xbit_r61_c31 WL[61] BL[31] BLB[31] VDD GND sram_bitcell
Xbit_r62_c0 WL[62] BL[0] BLB[0] VDD GND sram_bitcell
Xbit_r62_c1 WL[62] BL[1] BLB[1] VDD GND sram_bitcell
Xbit_r62_c2 WL[62] BL[2] BLB[2] VDD GND sram_bitcell
Xbit_r62_c3 WL[62] BL[3] BLB[3] VDD GND sram_bitcell
Xbit_r62_c4 WL[62] BL[4] BLB[4] VDD GND sram_bitcell
Xbit_r62_c5 WL[62] BL[5] BLB[5] VDD GND sram_bitcell
Xbit_r62_c6 WL[62] BL[6] BLB[6] VDD GND sram_bitcell
Xbit_r62_c7 WL[62] BL[7] BLB[7] VDD GND sram_bitcell
Xbit_r62_c8 WL[62] BL[8] BLB[8] VDD GND sram_bitcell
Xbit_r62_c9 WL[62] BL[9] BLB[9] VDD GND sram_bitcell
Xbit_r62_c10 WL[62] BL[10] BLB[10] VDD GND sram_bitcell
Xbit_r62_c11 WL[62] BL[11] BLB[11] VDD GND sram_bitcell
Xbit_r62_c12 WL[62] BL[12] BLB[12] VDD GND sram_bitcell
Xbit_r62_c13 WL[62] BL[13] BLB[13] VDD GND sram_bitcell
Xbit_r62_c14 WL[62] BL[14] BLB[14] VDD GND sram_bitcell
Xbit_r62_c15 WL[62] BL[15] BLB[15] VDD GND sram_bitcell
Xbit_r62_c16 WL[62] BL[16] BLB[16] VDD GND sram_bitcell
Xbit_r62_c17 WL[62] BL[17] BLB[17] VDD GND sram_bitcell
Xbit_r62_c18 WL[62] BL[18] BLB[18] VDD GND sram_bitcell
Xbit_r62_c19 WL[62] BL[19] BLB[19] VDD GND sram_bitcell
Xbit_r62_c20 WL[62] BL[20] BLB[20] VDD GND sram_bitcell
Xbit_r62_c21 WL[62] BL[21] BLB[21] VDD GND sram_bitcell
Xbit_r62_c22 WL[62] BL[22] BLB[22] VDD GND sram_bitcell
Xbit_r62_c23 WL[62] BL[23] BLB[23] VDD GND sram_bitcell
Xbit_r62_c24 WL[62] BL[24] BLB[24] VDD GND sram_bitcell
Xbit_r62_c25 WL[62] BL[25] BLB[25] VDD GND sram_bitcell
Xbit_r62_c26 WL[62] BL[26] BLB[26] VDD GND sram_bitcell
Xbit_r62_c27 WL[62] BL[27] BLB[27] VDD GND sram_bitcell
Xbit_r62_c28 WL[62] BL[28] BLB[28] VDD GND sram_bitcell
Xbit_r62_c29 WL[62] BL[29] BLB[29] VDD GND sram_bitcell
Xbit_r62_c30 WL[62] BL[30] BLB[30] VDD GND sram_bitcell
Xbit_r62_c31 WL[62] BL[31] BLB[31] VDD GND sram_bitcell
Xbit_r63_c0 WL[63] BL[0] BLB[0] VDD GND sram_bitcell
Xbit_r63_c1 WL[63] BL[1] BLB[1] VDD GND sram_bitcell
Xbit_r63_c2 WL[63] BL[2] BLB[2] VDD GND sram_bitcell
Xbit_r63_c3 WL[63] BL[3] BLB[3] VDD GND sram_bitcell
Xbit_r63_c4 WL[63] BL[4] BLB[4] VDD GND sram_bitcell
Xbit_r63_c5 WL[63] BL[5] BLB[5] VDD GND sram_bitcell
Xbit_r63_c6 WL[63] BL[6] BLB[6] VDD GND sram_bitcell
Xbit_r63_c7 WL[63] BL[7] BLB[7] VDD GND sram_bitcell
Xbit_r63_c8 WL[63] BL[8] BLB[8] VDD GND sram_bitcell
Xbit_r63_c9 WL[63] BL[9] BLB[9] VDD GND sram_bitcell
Xbit_r63_c10 WL[63] BL[10] BLB[10] VDD GND sram_bitcell
Xbit_r63_c11 WL[63] BL[11] BLB[11] VDD GND sram_bitcell
Xbit_r63_c12 WL[63] BL[12] BLB[12] VDD GND sram_bitcell
Xbit_r63_c13 WL[63] BL[13] BLB[13] VDD GND sram_bitcell
Xbit_r63_c14 WL[63] BL[14] BLB[14] VDD GND sram_bitcell
Xbit_r63_c15 WL[63] BL[15] BLB[15] VDD GND sram_bitcell
Xbit_r63_c16 WL[63] BL[16] BLB[16] VDD GND sram_bitcell
Xbit_r63_c17 WL[63] BL[17] BLB[17] VDD GND sram_bitcell
Xbit_r63_c18 WL[63] BL[18] BLB[18] VDD GND sram_bitcell
Xbit_r63_c19 WL[63] BL[19] BLB[19] VDD GND sram_bitcell
Xbit_r63_c20 WL[63] BL[20] BLB[20] VDD GND sram_bitcell
Xbit_r63_c21 WL[63] BL[21] BLB[21] VDD GND sram_bitcell
Xbit_r63_c22 WL[63] BL[22] BLB[22] VDD GND sram_bitcell
Xbit_r63_c23 WL[63] BL[23] BLB[23] VDD GND sram_bitcell
Xbit_r63_c24 WL[63] BL[24] BLB[24] VDD GND sram_bitcell
Xbit_r63_c25 WL[63] BL[25] BLB[25] VDD GND sram_bitcell
Xbit_r63_c26 WL[63] BL[26] BLB[26] VDD GND sram_bitcell
Xbit_r63_c27 WL[63] BL[27] BLB[27] VDD GND sram_bitcell
Xbit_r63_c28 WL[63] BL[28] BLB[28] VDD GND sram_bitcell
Xbit_r63_c29 WL[63] BL[29] BLB[29] VDD GND sram_bitcell
Xbit_r63_c30 WL[63] BL[30] BLB[30] VDD GND sram_bitcell
Xbit_r63_c31 WL[63] BL[31] BLB[31] VDD GND sram_bitcell
.ends
